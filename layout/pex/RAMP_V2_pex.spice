* NGSPICE file created from RAMP_V2.ext - technology: ihp-sg13g2

.subckt pc_pmos_8 a_268_0# a_896_n36# a_68_n36# a_344_n36# w_n62_n62# a_620_n36# sub  a_820_0# a_1096_0# a_544_0# a_0_0#
X0 a_820_0# a_620_n36# a_544_0# w_n62_n62# sg13_lv_pmos ad=0.38p pd=2.38u as=0.38p ps=2.38u w=2u l=1u
X1 a_544_0# a_344_n36# a_268_0# w_n62_n62# sg13_lv_pmos ad=0.38p pd=2.38u as=0.38p ps=2.38u w=2u l=1u
X2 a_1096_0# a_896_n36# a_820_0# w_n62_n62# sg13_lv_pmos ad=0.68p pd=4.68u as=0.38p ps=2.38u w=2u l=1u
X3 a_268_0# a_68_n36# a_0_0# w_n62_n62# sg13_lv_pmos ad=0.38p pd=2.38u as=0.68p ps=4.68u w=2u l=1u
C0 a_344_n36# a_268_0# 0.05528f
C1 a_544_0# w_n62_n62# 0.03593f
C2 a_820_0# a_896_n36# 0.05528f
C3 a_68_n36# a_0_0# 0.05528f
C4 a_344_n36# w_n62_n62# 0.23099f
C5 a_544_0# a_820_0# 0.05426f
C6 w_n62_n62# a_620_n36# 0.23099f
C7 a_344_n36# a_68_n36# 0.01172f
C8 a_1096_0# w_n62_n62# 0.03065f
C9 a_896_n36# a_620_n36# 0.01172f
C10 a_268_0# w_n62_n62# 0.03593f
C11 a_820_0# a_620_n36# 0.05528f
C12 a_344_n36# a_544_0# 0.05528f
C13 a_1096_0# a_896_n36# 0.05528f
C14 a_544_0# a_620_n36# 0.05528f
C15 a_820_0# a_1096_0# 0.05426f
C16 a_268_0# a_68_n36# 0.05528f
C17 a_268_0# a_0_0# 0.05426f
C18 a_344_n36# a_620_n36# 0.01172f
C19 a_268_0# a_544_0# 0.05426f
C20 w_n62_n62# a_896_n36# 0.23367f
C21 w_n62_n62# a_68_n36# 0.23367f
C22 a_820_0# w_n62_n62# 0.03593f
C23 w_n62_n62# a_0_0# 0.03065f
C24 a_1096_0# sub 0.07701f
C25 a_820_0# sub 0.01094f
C26 a_544_0# sub 0.01094f
C27 a_268_0# sub 0.01094f
C28 a_0_0# sub 0.07701f
C29 a_896_n36# sub 0.08376f
C30 a_620_n36# sub 0.0764f
C31 a_344_n36# sub 0.0764f
C32 a_68_n36# sub 0.08376f
.ends

.subckt pc_nmosHV_2 a_944_0# a_1496_n36# a_4752_0# a_1896_0# a_68_n36# a_3324_0# a_2372_0#  a_3400_n36# sub a_3800_0# a_2924_n36# a_4352_n36# a_1020_n36# a_2448_n36# a_4276_0#  a_468_0# a_1420_0# a_3876_n36# a_0_0# a_1972_n36# a_544_n36# a_2848_0#
X0 a_1896_0# a_1496_n36# a_1420_0# sub sg13_hv_nmos ad=57f pd=0.68u as=57f ps=0.68u w=0.3u l=2u
X1 a_2372_0# a_1972_n36# a_1896_0# sub sg13_hv_nmos ad=57f pd=0.68u as=57f ps=0.68u w=0.3u l=2u
X2 a_4276_0# a_3876_n36# a_3800_0# sub sg13_hv_nmos ad=57f pd=0.68u as=57f ps=0.68u w=0.3u l=2u
X3 a_2848_0# a_2448_n36# a_2372_0# sub sg13_hv_nmos ad=57f pd=0.68u as=57f ps=0.68u w=0.3u l=2u
X4 a_1420_0# a_1020_n36# a_944_0# sub sg13_hv_nmos ad=57f pd=0.68u as=57f ps=0.68u w=0.3u l=2u
X5 a_4752_0# a_4352_n36# a_4276_0# sub sg13_hv_nmos ad=0.102p pd=1.28u as=57f ps=0.68u w=0.3u l=2u
X6 a_944_0# a_544_n36# a_468_0# sub sg13_hv_nmos ad=57f pd=0.68u as=57f ps=0.68u w=0.3u l=2u
X7 a_3324_0# a_2924_n36# a_2848_0# sub sg13_hv_nmos ad=57f pd=0.68u as=57f ps=0.68u w=0.3u l=2u
X8 a_3800_0# a_3400_n36# a_3324_0# sub sg13_hv_nmos ad=57f pd=0.68u as=57f ps=0.68u w=0.3u l=2u
X9 a_468_0# a_68_n36# a_0_0# sub sg13_hv_nmos ad=57f pd=0.68u as=0.102p ps=1.28u w=0.3u l=2u
C0 a_468_0# a_544_n36# 0.01044f
C1 a_1972_n36# a_1896_0# 0.01044f
C2 a_4276_0# a_4352_n36# 0.01044f
C3 a_68_n36# a_544_n36# 0.01172f
C4 a_1496_n36# a_1896_0# 0.01044f
C5 a_3400_n36# a_3324_0# 0.01044f
C6 a_2924_n36# a_3400_n36# 0.01172f
C7 a_1020_n36# a_1420_0# 0.01044f
C8 a_3876_n36# a_4276_0# 0.01044f
C9 a_1496_n36# a_1972_n36# 0.01172f
C10 a_2924_n36# a_2848_0# 0.01044f
C11 a_0_0# a_68_n36# 0.01044f
C12 a_944_0# a_544_n36# 0.01044f
C13 a_1972_n36# a_2372_0# 0.01044f
C14 a_4752_0# a_4352_n36# 0.01044f
C15 a_2448_n36# a_2848_0# 0.01044f
C16 a_3400_n36# a_3800_0# 0.01044f
C17 a_1972_n36# a_2448_n36# 0.01172f
C18 a_2924_n36# a_3324_0# 0.01044f
C19 a_1496_n36# a_1420_0# 0.01044f
C20 a_1020_n36# a_544_n36# 0.01172f
C21 a_3876_n36# a_3800_0# 0.01044f
C22 a_3876_n36# a_3400_n36# 0.01172f
C23 a_3876_n36# a_4352_n36# 0.01172f
C24 a_1020_n36# a_1496_n36# 0.01172f
C25 a_468_0# a_68_n36# 0.01044f
C26 a_2924_n36# a_2448_n36# 0.01172f
C27 a_1020_n36# a_944_0# 0.01044f
C28 a_2448_n36# a_2372_0# 0.01044f
C29 a_4752_0# sub 0.02417f
C30 a_4276_0# sub 0.01267f
C31 a_3800_0# sub 0.01267f
C32 a_3324_0# sub 0.01267f
C33 a_2848_0# sub 0.01267f
C34 a_2372_0# sub 0.01267f
C35 a_1896_0# sub 0.01267f
C36 a_1420_0# sub 0.01267f
C37 a_944_0# sub 0.01267f
C38 a_468_0# sub 0.01267f
C39 a_0_0# sub 0.02417f
C40 a_4352_n36# sub 0.31558f
C41 a_3876_n36# sub 0.30553f
C42 a_3400_n36# sub 0.30553f
C43 a_2924_n36# sub 0.30553f
C44 a_2448_n36# sub 0.30553f
C45 a_1972_n36# sub 0.30553f
C46 a_1496_n36# sub 0.30553f
C47 a_1020_n36# sub 0.30553f
C48 a_544_n36# sub 0.30553f
C49 a_68_n36# sub 0.31558f
.ends

.subckt pc_nmos_10 a_442_15# a_100_15# a_328_15# a_188_n21# a_74_n21# a_670_15# sub a_556_15#  a_214_15# a_302_n21# a_0_0# a_416_n21# a_530_n21# a_644_n21#
X0 a_670_15# a_644_n21# a_556_15# sub sg13_lv_nmos ad=0.1005p pd=1.34u as=55.5f ps=0.74u w=0.15u l=0.13u
X1 a_328_15# a_302_n21# a_214_15# sub sg13_lv_nmos ad=55.5f pd=0.74u as=55.5f ps=0.74u w=0.15u l=0.13u
X2 a_556_15# a_530_n21# a_442_15# sub sg13_lv_nmos ad=55.5f pd=0.74u as=55.5f ps=0.74u w=0.15u l=0.13u
X3 a_100_15# a_74_n21# a_0_0# sub sg13_lv_nmos ad=55.5f pd=0.74u as=0.1005p ps=1.34u w=0.15u l=0.13u
X4 a_214_15# a_188_n21# a_100_15# sub sg13_lv_nmos ad=55.5f pd=0.74u as=55.5f ps=0.74u w=0.15u l=0.13u
X5 a_442_15# a_416_n21# a_328_15# sub sg13_lv_nmos ad=55.5f pd=0.74u as=55.5f ps=0.74u w=0.15u l=0.13u
C0 a_214_15# a_328_15# 0.02238f
C1 a_670_15# a_556_15# 0.02238f
C2 a_530_n21# a_416_n21# 0.01005f
C3 a_100_15# a_214_15# 0.02238f
C4 a_530_n21# a_644_n21# 0.01005f
C5 a_74_n21# a_188_n21# 0.01005f
C6 a_302_n21# a_416_n21# 0.01005f
C7 a_0_0# a_100_15# 0.02238f
C8 a_442_15# a_556_15# 0.02238f
C9 a_442_15# a_328_15# 0.02238f
C10 a_188_n21# a_302_n21# 0.01005f
C11 a_670_15# sub 0.02279f
C12 a_644_n21# sub 0.0401f
C13 a_556_15# sub 0.01308f
C14 a_530_n21# sub 0.03076f
C15 a_442_15# sub 0.01308f
C16 a_416_n21# sub 0.03076f
C17 a_328_15# sub 0.01308f
C18 a_302_n21# sub 0.03076f
C19 a_214_15# sub 0.01308f
C20 a_188_n21# sub 0.03076f
C21 a_100_15# sub 0.01308f
C22 a_74_n21# sub 0.0401f
C23 a_0_0# sub 0.02279f
.ends

.subckt pc_cmim sub c1_0_0# m5_n120_n120#
X0 c1_0_0# m5_n120_n120# cap_cmim l=51.6u w=51.6u
C0 c1_0_0# m5_n120_n120# 4.18997f
C1 c1_0_0# sub 7.40857f
C2 m5_n120_n120# sub 25.7077f
.ends

.subckt pc_rhigh a_0_1146# sub a_0_n86# a_0_0#
X0 a_0_1146# a_0_n86# sub rhigh l=5.73u w=0.5u
C0 a_0_0# a_0_1146# 0.01781f
C1 a_0_0# a_0_n86# 0.01781f
C2 a_0_n86# sub 0.11782f
C3 a_0_0# sub 0.76089f
C4 a_0_1146# sub 0.11782f
.ends

.subckt pc_pmos_6 a_268_0# a_68_n36# a_344_n36# w_n62_n62# sub a_544_0# a_0_0#
X0 a_544_0# a_344_n36# a_268_0# w_n62_n62# sg13_lv_pmos ad=1.36p pd=8.68u as=0.76p ps=4.38u w=4u l=1u
X1 a_268_0# a_68_n36# a_0_0# w_n62_n62# sg13_lv_pmos ad=0.76p pd=4.38u as=1.36p ps=8.68u w=4u l=1u
C0 a_68_n36# w_n62_n62# 0.40854f
C1 w_n62_n62# a_0_0# 0.05653f
C2 a_344_n36# w_n62_n62# 0.40854f
C3 a_68_n36# a_268_0# 0.11057f
C4 a_544_0# a_344_n36# 0.11057f
C5 a_268_0# a_0_0# 0.10853f
C6 a_344_n36# a_268_0# 0.11057f
C7 a_544_0# w_n62_n62# 0.05653f
C8 a_68_n36# a_0_0# 0.11057f
C9 w_n62_n62# a_268_0# 0.06444f
C10 a_68_n36# a_344_n36# 0.01172f
C11 a_544_0# a_268_0# 0.10853f
C12 a_544_0# sub 0.14307f
C13 a_268_0# sub 0.01094f
C14 a_0_0# sub 0.14307f
C15 a_344_n36# sub 0.08376f
C16 a_68_n36# sub 0.08376f
.ends

.subckt pc_nmos_9 a_442_15# a_100_15# a_328_15# a_188_n21# a_74_n21# sub a_214_15# a_302_n21#  a_0_0# a_416_n21#
X0 a_328_15# a_302_n21# a_214_15# sub sg13_lv_nmos ad=55.5f pd=0.74u as=55.5f ps=0.74u w=0.15u l=0.13u
X1 a_100_15# a_74_n21# a_0_0# sub sg13_lv_nmos ad=55.5f pd=0.74u as=0.1005p ps=1.34u w=0.15u l=0.13u
X2 a_214_15# a_188_n21# a_100_15# sub sg13_lv_nmos ad=55.5f pd=0.74u as=55.5f ps=0.74u w=0.15u l=0.13u
X3 a_442_15# a_416_n21# a_328_15# sub sg13_lv_nmos ad=0.1005p pd=1.34u as=55.5f ps=0.74u w=0.15u l=0.13u
C0 a_302_n21# a_188_n21# 0.01005f
C1 a_100_15# a_0_0# 0.02238f
C2 a_328_15# a_442_15# 0.02238f
C3 a_100_15# a_214_15# 0.02238f
C4 a_302_n21# a_416_n21# 0.01005f
C5 a_74_n21# a_188_n21# 0.01005f
C6 a_328_15# a_214_15# 0.02238f
C7 a_442_15# sub 0.02279f
C8 a_416_n21# sub 0.0401f
C9 a_328_15# sub 0.01308f
C10 a_302_n21# sub 0.03076f
C11 a_214_15# sub 0.01308f
C12 a_188_n21# sub 0.03076f
C13 a_100_15# sub 0.01308f
C14 a_74_n21# sub 0.0401f
C15 a_0_0# sub 0.02279f
.ends

.subckt pc_pmos_4 a_268_0# a_68_n36# w_n62_n62# sub a_0_0#
X0 a_268_0# a_68_n36# a_0_0# w_n62_n62# sg13_lv_pmos ad=1.36p pd=8.68u as=1.36p ps=8.68u w=4u l=1u
C0 a_268_0# a_68_n36# 0.11057f
C1 a_268_0# w_n62_n62# 0.05653f
C2 a_0_0# a_68_n36# 0.11057f
C3 w_n62_n62# a_0_0# 0.05653f
C4 a_268_0# a_0_0# 0.10853f
C5 w_n62_n62# a_68_n36# 0.41122f
C6 a_268_0# sub 0.14307f
C7 a_0_0# sub 0.14307f
C8 a_68_n36# sub 0.09113f
.ends

.subckt pc_cmim_1 sub c1_0_0# m5_n120_n120#
X0 c1_0_0# m5_n120_n120# cap_cmim l=25.8u w=25.8u
C0 m5_n120_n120# c1_0_0# 1.70963f
C1 c1_0_0# sub 3.6064f
C2 m5_n120_n120# sub 8.17506f
.ends

.subckt pc_nmos_7 a_944_0# a_68_n36# sub a_1020_n36# a_468_0# a_1420_0# a_0_0# a_544_n36#
X0 a_1420_0# a_1020_n36# a_944_0# sub sg13_lv_nmos ad=0.34p pd=2.68u as=0.19p ps=1.38u w=1u l=2u
X1 a_944_0# a_544_n36# a_468_0# sub sg13_lv_nmos ad=0.19p pd=1.38u as=0.19p ps=1.38u w=1u l=2u
X2 a_468_0# a_68_n36# a_0_0# sub sg13_lv_nmos ad=0.19p pd=1.38u as=0.34p ps=2.68u w=1u l=2u
C0 a_544_n36# a_944_0# 0.03479f
C1 a_1420_0# a_944_0# 0.01424f
C2 a_468_0# a_544_n36# 0.03479f
C3 a_0_0# a_68_n36# 0.03479f
C4 a_1020_n36# a_544_n36# 0.01172f
C5 a_68_n36# a_468_0# 0.03479f
C6 a_468_0# a_944_0# 0.01424f
C7 a_1020_n36# a_1420_0# 0.03479f
C8 a_1020_n36# a_944_0# 0.03479f
C9 a_0_0# a_468_0# 0.01424f
C10 a_68_n36# a_544_n36# 0.01172f
C11 a_1420_0# sub 0.05102f
C12 a_944_0# sub 0.01267f
C13 a_468_0# sub 0.01267f
C14 a_0_0# sub 0.05102f
C15 a_1020_n36# sub 0.43798f
C16 a_544_n36# sub 0.42794f
C17 a_68_n36# sub 0.43798f
.ends

.subckt pc_pmos_2 a_100_15# w_n62_n62# a_74_n21# sub a_0_0#
X0 a_100_15# a_74_n21# a_0_0# w_n62_n62# sg13_lv_pmos ad=0.1005p pd=1.34u as=0.1005p ps=1.34u w=0.15u l=0.13u
C0 a_0_0# a_100_15# 0.02238f
C1 w_n62_n62# a_74_n21# 0.02613f
C2 a_100_15# sub 0.01942f
C3 a_74_n21# sub 0.02332f
C4 a_0_0# sub 0.01942f
.ends

.subckt pc_nmos_5 a_68_n36# sub a_468_0# a_0_0#
X0 a_468_0# a_68_n36# a_0_0# sub sg13_lv_nmos ad=0.34p pd=2.68u as=0.34p ps=2.68u w=1u l=2u
C0 a_68_n36# a_468_0# 0.03479f
C1 a_0_0# a_468_0# 0.01424f
C2 a_68_n36# a_0_0# 0.03479f
C3 a_468_0# sub 0.05102f
C4 a_0_0# sub 0.05102f
C5 a_68_n36# sub 0.44803f
.ends

.subckt pc_nmosHV_7 a_268_0# a_896_n36# a_68_n36# a_344_n36# a_1648_0# a_1172_n36# a_1372_0#  a_620_n36# sub a_820_0# a_1448_n36# a_1096_0# a_544_0# a_0_0#
X0 a_820_0# a_620_n36# a_544_0# sub sg13_hv_nmos ad=0.2185p pd=1.53u as=0.2185p ps=1.53u w=1.15u l=1u
X1 a_544_0# a_344_n36# a_268_0# sub sg13_hv_nmos ad=0.2185p pd=1.53u as=0.2185p ps=1.53u w=1.15u l=1u
X2 a_1096_0# a_896_n36# a_820_0# sub sg13_hv_nmos ad=0.2185p pd=1.53u as=0.2185p ps=1.53u w=1.15u l=1u
X3 a_1648_0# a_1448_n36# a_1372_0# sub sg13_hv_nmos ad=0.391p pd=2.98u as=0.2185p ps=1.53u w=1.15u l=1u
X4 a_268_0# a_68_n36# a_0_0# sub sg13_hv_nmos ad=0.2185p pd=1.53u as=0.391p ps=2.98u w=1.15u l=1u
X5 a_1372_0# a_1172_n36# a_1096_0# sub sg13_hv_nmos ad=0.2185p pd=1.53u as=0.2185p ps=1.53u w=1.15u l=1u
C0 a_1372_0# a_1448_n36# 0.03179f
C1 a_1096_0# a_820_0# 0.03123f
C2 a_1096_0# a_1172_n36# 0.03179f
C3 a_1372_0# a_1648_0# 0.03123f
C4 a_1096_0# a_1372_0# 0.03123f
C5 a_896_n36# a_620_n36# 0.01172f
C6 a_544_0# a_620_n36# 0.03179f
C7 a_268_0# a_68_n36# 0.03179f
C8 a_268_0# a_344_n36# 0.03179f
C9 a_68_n36# a_0_0# 0.03179f
C10 a_820_0# a_896_n36# 0.03179f
C11 a_544_0# a_820_0# 0.03123f
C12 a_1172_n36# a_896_n36# 0.01172f
C13 a_820_0# a_620_n36# 0.03179f
C14 a_1648_0# a_1448_n36# 0.03179f
C15 a_544_0# a_344_n36# 0.03179f
C16 a_344_n36# a_620_n36# 0.01172f
C17 a_1372_0# a_1172_n36# 0.03179f
C18 a_268_0# a_0_0# 0.03123f
C19 a_1096_0# a_896_n36# 0.03179f
C20 a_68_n36# a_344_n36# 0.01172f
C21 a_268_0# a_544_0# 0.03123f
C22 a_1172_n36# a_1448_n36# 0.01172f
C23 a_1648_0# sub 0.05677f
C24 a_1372_0# sub 0.01267f
C25 a_1096_0# sub 0.01267f
C26 a_820_0# sub 0.01267f
C27 a_544_0# sub 0.01267f
C28 a_268_0# sub 0.01267f
C29 a_0_0# sub 0.05677f
C30 a_1448_n36# sub 0.24312f
C31 a_1172_n36# sub 0.23307f
C32 a_896_n36# sub 0.23307f
C33 a_620_n36# sub 0.23307f
C34 a_344_n36# sub 0.23307f
C35 a_68_n36# sub 0.24312f
.ends

.subckt pc_pmosHV_4 a_1300_n36# a_1400_0# a_68_n36# a_344_0# a_872_0# a_948_n36# a_244_n36#  w_n124_n124# a_1048_0# sub a_520_0# a_596_n36# a_1124_n36# a_420_n36# a_1224_0#  a_168_0# a_0_0# a_696_0# a_772_n36#
X0 a_1224_0# a_1124_n36# a_1048_0# w_n124_n124# sg13_hv_pmos ad=0.855p pd=4.88u as=0.855p ps=4.88u w=4.5u l=0.5u
X1 a_872_0# a_772_n36# a_696_0# w_n124_n124# sg13_hv_pmos ad=0.855p pd=4.88u as=0.855p ps=4.88u w=4.5u l=0.5u
X2 a_520_0# a_420_n36# a_344_0# w_n124_n124# sg13_hv_pmos ad=0.855p pd=4.88u as=0.855p ps=4.88u w=4.5u l=0.5u
X3 a_696_0# a_596_n36# a_520_0# w_n124_n124# sg13_hv_pmos ad=0.855p pd=4.88u as=0.855p ps=4.88u w=4.5u l=0.5u
X4 a_168_0# a_68_n36# a_0_0# w_n124_n124# sg13_hv_pmos ad=0.855p pd=4.88u as=1.53p ps=9.68u w=4.5u l=0.5u
X5 a_344_0# a_244_n36# a_168_0# w_n124_n124# sg13_hv_pmos ad=0.855p pd=4.88u as=0.855p ps=4.88u w=4.5u l=0.5u
X6 a_1048_0# a_948_n36# a_872_0# w_n124_n124# sg13_hv_pmos ad=0.855p pd=4.88u as=0.855p ps=4.88u w=4.5u l=0.5u
X7 a_1400_0# a_1300_n36# a_1224_0# w_n124_n124# sg13_hv_pmos ad=1.53p pd=9.68u as=0.855p ps=4.88u w=4.5u l=0.5u
C0 a_1224_0# a_1400_0# 0.21362f
C1 w_n124_n124# a_344_0# 0.05226f
C2 a_420_n36# a_520_0# 0.08394f
C3 a_596_n36# a_772_n36# 0.01172f
C4 a_420_n36# a_596_n36# 0.01172f
C5 a_244_n36# a_344_0# 0.08394f
C6 a_1048_0# a_1124_n36# 0.08394f
C7 a_68_n36# a_0_0# 0.08394f
C8 a_520_0# w_n124_n124# 0.05226f
C9 a_1124_n36# w_n124_n124# 0.24303f
C10 a_68_n36# a_168_0# 0.08394f
C11 a_1224_0# a_1124_n36# 0.08394f
C12 a_596_n36# w_n124_n124# 0.24303f
C13 a_520_0# a_696_0# 0.21362f
C14 a_0_0# w_n124_n124# 0.07584f
C15 a_596_n36# a_696_0# 0.08394f
C16 a_1124_n36# a_948_n36# 0.01172f
C17 a_168_0# w_n124_n124# 0.05226f
C18 a_520_0# a_344_0# 0.21362f
C19 a_1300_n36# w_n124_n124# 0.24759f
C20 a_244_n36# a_168_0# 0.08394f
C21 a_1224_0# a_1300_n36# 0.08394f
C22 a_872_0# a_772_n36# 0.08394f
C23 a_168_0# a_344_0# 0.21362f
C24 a_1400_0# a_1300_n36# 0.08394f
C25 a_872_0# a_1048_0# 0.21362f
C26 a_520_0# a_596_n36# 0.08394f
C27 a_872_0# w_n124_n124# 0.05226f
C28 a_772_n36# w_n124_n124# 0.24303f
C29 a_420_n36# w_n124_n124# 0.24303f
C30 a_872_0# a_696_0# 0.21362f
C31 a_772_n36# a_696_0# 0.08394f
C32 a_872_0# a_948_n36# 0.08394f
C33 a_68_n36# w_n124_n124# 0.24759f
C34 a_1048_0# w_n124_n124# 0.05226f
C35 a_1048_0# a_1224_0# 0.21362f
C36 a_772_n36# a_948_n36# 0.01172f
C37 a_0_0# a_168_0# 0.21362f
C38 a_244_n36# a_420_n36# 0.01172f
C39 a_1124_n36# a_1300_n36# 0.01172f
C40 a_1048_0# a_948_n36# 0.08394f
C41 a_1224_0# w_n124_n124# 0.05226f
C42 a_68_n36# a_244_n36# 0.01172f
C43 a_420_n36# a_344_0# 0.08394f
C44 a_696_0# w_n124_n124# 0.05226f
C45 w_n124_n124# a_948_n36# 0.24303f
C46 a_244_n36# w_n124_n124# 0.24303f
C47 a_1400_0# w_n124_n124# 0.07584f
C48 a_1400_0# sub 0.13645f
C49 a_0_0# sub 0.13645f
C50 a_1300_n36# sub 0.03143f
C51 a_1124_n36# sub 0.02594f
C52 a_948_n36# sub 0.02594f
C53 a_772_n36# sub 0.02594f
C54 a_596_n36# sub 0.02594f
C55 a_420_n36# sub 0.02594f
C56 a_244_n36# sub 0.02594f
C57 a_68_n36# sub 0.03143f
.ends

.subckt pc_nmos_3 a_100_15# a_188_n21# a_74_n21# sub a_214_15# a_0_0#
X0 a_100_15# a_74_n21# a_0_0# sub sg13_lv_nmos ad=55.5f pd=0.74u as=0.1005p ps=1.34u w=0.15u l=0.13u
X1 a_214_15# a_188_n21# a_100_15# sub sg13_lv_nmos ad=0.1005p pd=1.34u as=55.5f ps=0.74u w=0.15u l=0.13u
C0 a_100_15# a_214_15# 0.02238f
C1 a_188_n21# a_74_n21# 0.01005f
C2 a_100_15# a_0_0# 0.02238f
C3 a_214_15# sub 0.02279f
C4 a_188_n21# sub 0.0401f
C5 a_100_15# sub 0.01308f
C6 a_74_n21# sub 0.0401f
C7 a_0_0# sub 0.02279f
.ends

.subckt pc_nmosHV_5 a_68_n36# a_668_0# sub a_0_0#
X0 a_668_0# a_68_n36# a_0_0# sub sg13_hv_nmos ad=1.02p pd=6.68u as=1.02p ps=6.68u w=3u l=3u
C0 a_0_0# a_68_n36# 0.11296f
C1 a_668_0# a_0_0# 0.02872f
C2 a_668_0# a_68_n36# 0.11296f
C3 a_668_0# sub 0.12772f
C4 a_0_0# sub 0.12772f
C5 a_68_n36# sub 1.18061f
.ends

.subckt pc_pmosHV_2 a_268_0# a_68_n36# w_n124_n124# sub a_0_0#
X0 a_268_0# a_68_n36# a_0_0# w_n124_n124# sg13_hv_pmos ad=0.34p pd=2.68u as=0.34p ps=2.68u w=1u l=1u
C0 a_68_n36# w_n124_n124# 0.17719f
C1 a_0_0# a_268_0# 0.02715f
C2 a_0_0# a_68_n36# 0.02764f
C3 a_268_0# a_68_n36# 0.02764f
C4 a_0_0# w_n124_n124# 0.02256f
C5 a_268_0# w_n124_n124# 0.02256f
C6 a_268_0# sub 0.03761f
C7 a_0_0# sub 0.03761f
C8 a_68_n36# sub 0.06285f
.ends

.subckt pc_nmos a_68_n36# a_3420_n36# sub a_6696_0# a_5020_0# a_1744_n36# a_3344_0# a_5096_n36#  a_0_0# a_1668_0#
X0 a_6696_0# a_5096_n36# a_5020_0# sub sg13_lv_nmos ad=0.17p pd=1.68u as=95f ps=0.88u w=0.5u l=8u
X1 a_3344_0# a_1744_n36# a_1668_0# sub sg13_lv_nmos ad=95f pd=0.88u as=95f ps=0.88u w=0.5u l=8u
X2 a_5020_0# a_3420_n36# a_3344_0# sub sg13_lv_nmos ad=95f pd=0.88u as=95f ps=0.88u w=0.5u l=8u
X3 a_1668_0# a_68_n36# a_0_0# sub sg13_lv_nmos ad=95f pd=0.88u as=0.17p ps=1.68u w=0.5u l=8u
C0 a_1668_0# a_1744_n36# 0.02075f
C1 a_0_0# a_68_n36# 0.02075f
C2 a_1744_n36# a_68_n36# 0.01172f
C3 a_3420_n36# a_3344_0# 0.02075f
C4 a_1668_0# a_68_n36# 0.02075f
C5 a_3344_0# a_1744_n36# 0.02075f
C6 a_3420_n36# a_5020_0# 0.02075f
C7 a_5096_n36# a_5020_0# 0.02075f
C8 a_3420_n36# a_5096_n36# 0.01172f
C9 a_3420_n36# a_1744_n36# 0.01172f
C10 a_5096_n36# a_6696_0# 0.02075f
C11 a_6696_0# sub 0.03407f
C12 a_5020_0# sub 0.01712f
C13 a_3344_0# sub 0.01712f
C14 a_1668_0# sub 0.01712f
C15 a_0_0# sub 0.03407f
C16 a_5096_n36# sub 1.33615f
C17 a_3420_n36# sub 1.3261f
C18 a_1744_n36# sub 1.3261f
C19 a_68_n36# sub 1.33615f
.ends

.subckt pc_nmos_1 a_68_n36# a_3420_n36# sub a_5020_0# a_1744_n36# a_3344_0# a_0_0# a_1668_0#
X0 a_3344_0# a_1744_n36# a_1668_0# sub sg13_lv_nmos ad=95f pd=0.88u as=95f ps=0.88u w=0.5u l=8u
X1 a_5020_0# a_3420_n36# a_3344_0# sub sg13_lv_nmos ad=0.17p pd=1.68u as=95f ps=0.88u w=0.5u l=8u
X2 a_1668_0# a_68_n36# a_0_0# sub sg13_lv_nmos ad=95f pd=0.88u as=0.17p ps=1.68u w=0.5u l=8u
C0 a_1744_n36# a_1668_0# 0.02075f
C1 a_5020_0# a_3420_n36# 0.02075f
C2 a_0_0# a_68_n36# 0.02075f
C3 a_3420_n36# a_3344_0# 0.02075f
C4 a_1744_n36# a_3344_0# 0.02075f
C5 a_1744_n36# a_3420_n36# 0.01172f
C6 a_68_n36# a_1668_0# 0.02075f
C7 a_1744_n36# a_68_n36# 0.01172f
C8 a_5020_0# sub 0.03407f
C9 a_3344_0# sub 0.01712f
C10 a_1668_0# sub 0.01712f
C11 a_0_0# sub 0.03407f
C12 a_3420_n36# sub 1.33615f
C13 a_1744_n36# sub 1.3261f
C14 a_68_n36# sub 1.33615f
.ends

.subckt pc_pmos_9 a_442_15# a_100_15# a_758_n21# a_872_n21# a_986_n21# a_328_15# w_n62_n62#  a_188_n21# a_74_n21# a_670_15# sub a_898_15# a_556_15# a_214_15# a_1012_15# a_302_n21#  a_0_0# a_416_n21# a_530_n21# a_784_15# a_644_n21#
X0 a_670_15# a_644_n21# a_556_15# w_n62_n62# sg13_lv_pmos ad=55.5f pd=0.74u as=55.5f ps=0.74u w=0.15u l=0.13u
X1 a_898_15# a_872_n21# a_784_15# w_n62_n62# sg13_lv_pmos ad=55.5f pd=0.74u as=55.5f ps=0.74u w=0.15u l=0.13u
X2 a_328_15# a_302_n21# a_214_15# w_n62_n62# sg13_lv_pmos ad=55.5f pd=0.74u as=55.5f ps=0.74u w=0.15u l=0.13u
X3 a_556_15# a_530_n21# a_442_15# w_n62_n62# sg13_lv_pmos ad=55.5f pd=0.74u as=55.5f ps=0.74u w=0.15u l=0.13u
X4 a_100_15# a_74_n21# a_0_0# w_n62_n62# sg13_lv_pmos ad=55.5f pd=0.74u as=0.1005p ps=1.34u w=0.15u l=0.13u
X5 a_784_15# a_758_n21# a_670_15# w_n62_n62# sg13_lv_pmos ad=55.5f pd=0.74u as=55.5f ps=0.74u w=0.15u l=0.13u
X6 a_214_15# a_188_n21# a_100_15# w_n62_n62# sg13_lv_pmos ad=55.5f pd=0.74u as=55.5f ps=0.74u w=0.15u l=0.13u
X7 a_1012_15# a_986_n21# a_898_15# w_n62_n62# sg13_lv_pmos ad=0.1005p pd=1.34u as=55.5f ps=0.74u w=0.15u l=0.13u
X8 a_442_15# a_416_n21# a_328_15# w_n62_n62# sg13_lv_pmos ad=55.5f pd=0.74u as=55.5f ps=0.74u w=0.15u l=0.13u
C0 a_758_n21# a_644_n21# 0.01005f
C1 w_n62_n62# a_986_n21# 0.02392f
C2 a_758_n21# a_872_n21# 0.01005f
C3 a_784_15# a_898_15# 0.02238f
C4 a_530_n21# w_n62_n62# 0.02172f
C5 a_188_n21# w_n62_n62# 0.02172f
C6 w_n62_n62# a_416_n21# 0.02172f
C7 a_188_n21# a_302_n21# 0.01005f
C8 a_442_15# a_556_15# 0.02238f
C9 w_n62_n62# a_758_n21# 0.02172f
C10 w_n62_n62# a_74_n21# 0.02392f
C11 a_670_15# a_556_15# 0.02238f
C12 w_n62_n62# a_644_n21# 0.02172f
C13 a_302_n21# a_416_n21# 0.01005f
C14 w_n62_n62# a_872_n21# 0.02172f
C15 a_898_15# a_1012_15# 0.02238f
C16 a_872_n21# a_986_n21# 0.01005f
C17 a_670_15# a_784_15# 0.02238f
C18 a_442_15# a_328_15# 0.02238f
C19 a_530_n21# a_416_n21# 0.01005f
C20 a_214_15# a_328_15# 0.02238f
C21 a_100_15# a_214_15# 0.02238f
C22 a_530_n21# a_644_n21# 0.01005f
C23 a_188_n21# a_74_n21# 0.01005f
C24 a_100_15# a_0_0# 0.02238f
C25 w_n62_n62# a_302_n21# 0.02172f
C26 a_1012_15# sub 0.01942f
C27 a_986_n21# sub 0.01618f
C28 a_898_15# sub 0.01084f
C29 a_784_15# sub 0.01084f
C30 a_670_15# sub 0.01084f
C31 a_556_15# sub 0.01084f
C32 a_442_15# sub 0.01084f
C33 a_328_15# sub 0.01084f
C34 a_214_15# sub 0.01084f
C35 a_100_15# sub 0.01084f
C36 a_74_n21# sub 0.01618f
C37 a_0_0# sub 0.01942f
.ends

.subckt pc_nmosHV_3 a_68_n36# sub a_0_0# a_868_0#
X0 a_868_0# a_68_n36# a_0_0# sub sg13_hv_nmos ad=1.36p pd=8.68u as=1.36p ps=8.68u w=4u l=4u
C0 a_68_n36# a_868_0# 0.15667f
C1 a_68_n36# a_0_0# 0.15667f
C2 a_0_0# a_868_0# 0.02877f
C3 a_868_0# sub 0.16607f
C4 a_0_0# sub 0.16607f
C5 a_68_n36# sub 1.91319f
.ends

.subckt pc_nmosHV a_68_n36# sub a_468_0# a_0_0#
X0 a_468_0# a_68_n36# a_0_0# sub sg13_hv_nmos ad=0.102p pd=1.28u as=0.102p ps=1.28u w=0.3u l=2u
C0 a_68_n36# a_468_0# 0.01044f
C1 a_68_n36# a_0_0# 0.01044f
C2 a_468_0# sub 0.02417f
C3 a_0_0# sub 0.02417f
C4 a_68_n36# sub 0.32563f
.ends

.subckt pc_pmos_7 a_268_0# a_68_n36# w_n62_n62# sub a_0_0#
X0 a_268_0# a_68_n36# a_0_0# w_n62_n62# sg13_lv_pmos ad=0.68p pd=4.68u as=0.68p ps=4.68u w=2u l=1u
C0 w_n62_n62# a_0_0# 0.03065f
C1 a_68_n36# a_268_0# 0.05528f
C2 w_n62_n62# a_268_0# 0.03065f
C3 a_0_0# a_268_0# 0.05426f
C4 w_n62_n62# a_68_n36# 0.23635f
C5 a_68_n36# a_0_0# 0.05528f
C6 a_268_0# sub 0.07701f
C7 a_0_0# sub 0.07701f
C8 a_68_n36# sub 0.09113f
.ends

.subckt pc_nmosHV_1 a_944_0# a_1496_n36# a_4752_0# a_1896_0# a_68_n36# a_3324_0# a_5304_n36#  a_2372_0# a_6732_n36# a_3400_n36# sub a_6656_0# a_3800_0# a_4828_n36# a_6256_n36#  a_2924_n36# a_5228_0# a_4352_n36# a_5780_n36# a_1020_n36# a_7132_0# a_2448_n36#  a_4276_0# a_468_0# a_1420_0# a_3876_n36# a_0_0# a_1972_n36# a_6180_0# a_5704_0#  a_544_n36# a_2848_0#
X0 a_1896_0# a_1496_n36# a_1420_0# sub sg13_hv_nmos ad=57f pd=0.68u as=57f ps=0.68u w=0.3u l=2u
X1 a_2372_0# a_1972_n36# a_1896_0# sub sg13_hv_nmos ad=57f pd=0.68u as=57f ps=0.68u w=0.3u l=2u
X2 a_4276_0# a_3876_n36# a_3800_0# sub sg13_hv_nmos ad=57f pd=0.68u as=57f ps=0.68u w=0.3u l=2u
X3 a_2848_0# a_2448_n36# a_2372_0# sub sg13_hv_nmos ad=57f pd=0.68u as=57f ps=0.68u w=0.3u l=2u
X4 a_1420_0# a_1020_n36# a_944_0# sub sg13_hv_nmos ad=57f pd=0.68u as=57f ps=0.68u w=0.3u l=2u
X5 a_6180_0# a_5780_n36# a_5704_0# sub sg13_hv_nmos ad=57f pd=0.68u as=57f ps=0.68u w=0.3u l=2u
X6 a_4752_0# a_4352_n36# a_4276_0# sub sg13_hv_nmos ad=57f pd=0.68u as=57f ps=0.68u w=0.3u l=2u
X7 a_944_0# a_544_n36# a_468_0# sub sg13_hv_nmos ad=57f pd=0.68u as=57f ps=0.68u w=0.3u l=2u
X8 a_3324_0# a_2924_n36# a_2848_0# sub sg13_hv_nmos ad=57f pd=0.68u as=57f ps=0.68u w=0.3u l=2u
X9 a_6656_0# a_6256_n36# a_6180_0# sub sg13_hv_nmos ad=57f pd=0.68u as=57f ps=0.68u w=0.3u l=2u
X10 a_5228_0# a_4828_n36# a_4752_0# sub sg13_hv_nmos ad=57f pd=0.68u as=57f ps=0.68u w=0.3u l=2u
X11 a_3800_0# a_3400_n36# a_3324_0# sub sg13_hv_nmos ad=57f pd=0.68u as=57f ps=0.68u w=0.3u l=2u
X12 a_7132_0# a_6732_n36# a_6656_0# sub sg13_hv_nmos ad=0.102p pd=1.28u as=57f ps=0.68u w=0.3u l=2u
X13 a_468_0# a_68_n36# a_0_0# sub sg13_hv_nmos ad=57f pd=0.68u as=0.102p ps=1.28u w=0.3u l=2u
X14 a_5704_0# a_5304_n36# a_5228_0# sub sg13_hv_nmos ad=57f pd=0.68u as=57f ps=0.68u w=0.3u l=2u
C0 a_5304_n36# a_5228_0# 0.01044f
C1 a_1420_0# a_1020_n36# 0.01044f
C2 a_468_0# a_544_n36# 0.01044f
C3 a_2924_n36# a_2448_n36# 0.01172f
C4 a_3400_n36# a_2924_n36# 0.01172f
C5 a_1496_n36# a_1972_n36# 0.01172f
C6 a_4276_0# a_4352_n36# 0.01044f
C7 a_5780_n36# a_6256_n36# 0.01172f
C8 a_6732_n36# a_6656_0# 0.01044f
C9 a_944_0# a_1020_n36# 0.01044f
C10 a_3876_n36# a_4352_n36# 0.01172f
C11 a_6732_n36# a_6256_n36# 0.01172f
C12 a_6256_n36# a_6180_0# 0.01044f
C13 a_5780_n36# a_5704_0# 0.01044f
C14 a_3876_n36# a_3800_0# 0.01044f
C15 a_4752_0# a_4352_n36# 0.01044f
C16 a_1896_0# a_1496_n36# 0.01044f
C17 a_2924_n36# a_3324_0# 0.01044f
C18 a_2848_0# a_2924_n36# 0.01044f
C19 a_3400_n36# a_3324_0# 0.01044f
C20 a_2848_0# a_2448_n36# 0.01044f
C21 a_1896_0# a_1972_n36# 0.01044f
C22 a_0_0# a_68_n36# 0.01044f
C23 a_468_0# a_68_n36# 0.01044f
C24 a_2372_0# a_1972_n36# 0.01044f
C25 a_5304_n36# a_5704_0# 0.01044f
C26 a_1420_0# a_1496_n36# 0.01044f
C27 a_4752_0# a_4828_n36# 0.01044f
C28 a_1020_n36# a_1496_n36# 0.01172f
C29 a_6732_n36# a_7132_0# 0.01044f
C30 a_3400_n36# a_3876_n36# 0.01172f
C31 a_4828_n36# a_4352_n36# 0.01172f
C32 a_68_n36# a_544_n36# 0.01172f
C33 a_6256_n36# a_6656_0# 0.01044f
C34 a_5780_n36# a_6180_0# 0.01044f
C35 a_1972_n36# a_2448_n36# 0.01172f
C36 a_544_n36# a_1020_n36# 0.01172f
C37 a_3400_n36# a_3800_0# 0.01044f
C38 a_944_0# a_544_n36# 0.01044f
C39 a_5304_n36# a_5780_n36# 0.01172f
C40 a_2372_0# a_2448_n36# 0.01044f
C41 a_5228_0# a_4828_n36# 0.01044f
C42 a_4276_0# a_3876_n36# 0.01044f
C43 a_5304_n36# a_4828_n36# 0.01172f
C44 a_7132_0# sub 0.02417f
C45 a_6656_0# sub 0.01267f
C46 a_6180_0# sub 0.01267f
C47 a_5704_0# sub 0.01267f
C48 a_5228_0# sub 0.01267f
C49 a_4752_0# sub 0.01267f
C50 a_4276_0# sub 0.01267f
C51 a_3800_0# sub 0.01267f
C52 a_3324_0# sub 0.01267f
C53 a_2848_0# sub 0.01267f
C54 a_2372_0# sub 0.01267f
C55 a_1896_0# sub 0.01267f
C56 a_1420_0# sub 0.01267f
C57 a_944_0# sub 0.01267f
C58 a_468_0# sub 0.01267f
C59 a_0_0# sub 0.02417f
C60 a_6732_n36# sub 0.31558f
C61 a_6256_n36# sub 0.30553f
C62 a_5780_n36# sub 0.30553f
C63 a_5304_n36# sub 0.30553f
C64 a_4828_n36# sub 0.30553f
C65 a_4352_n36# sub 0.30553f
C66 a_3876_n36# sub 0.30553f
C67 a_3400_n36# sub 0.30553f
C68 a_2924_n36# sub 0.30553f
C69 a_2448_n36# sub 0.30553f
C70 a_1972_n36# sub 0.30553f
C71 a_1496_n36# sub 0.30553f
C72 a_1020_n36# sub 0.30553f
C73 a_544_n36# sub 0.30553f
C74 a_68_n36# sub 0.31558f
.ends

.subckt pc_pmos_5 a_6416_n36# a_3656_n36# a_268_0# a_896_n36# a_4484_n36# a_3104_n36#  a_68_n36# a_6616_0# a_3932_n36# a_344_n36# a_6340_0# a_5512_0# w_n62_n62# a_1648_0#  a_1172_n36# a_2476_0# a_1372_0# a_4760_n36# a_620_n36# sub a_820_0# a_5588_n36#  a_4208_n36# a_1448_n36# a_5236_0# a_4408_0# a_3304_0# a_5036_n36# a_6064_0# a_4132_0#  a_2200_0# a_2276_n36# a_5864_n36# a_1724_n36# a_6892_0# a_4960_0# a_1096_0# a_6692_n36#  a_5312_n36# a_2552_n36# a_544_0# a_6140_n36# a_0_0# a_3380_n36# a_2000_n36# a_3028_0#  a_2828_n36# a_5788_0# a_4684_0# a_3856_0# a_2752_0# a_1924_0# a_3580_0#
X0 a_820_0# a_620_n36# a_544_0# w_n62_n62# sg13_lv_pmos ad=0.76p pd=4.38u as=0.76p ps=4.38u w=4u l=1u
X1 a_3856_0# a_3656_n36# a_3580_0# w_n62_n62# sg13_lv_pmos ad=0.76p pd=4.38u as=0.76p ps=4.38u w=4u l=1u
X2 a_6616_0# a_6416_n36# a_6340_0# w_n62_n62# sg13_lv_pmos ad=0.76p pd=4.38u as=0.76p ps=4.38u w=4u l=1u
X3 a_3028_0# a_2828_n36# a_2752_0# w_n62_n62# sg13_lv_pmos ad=0.76p pd=4.38u as=0.76p ps=4.38u w=4u l=1u
X4 a_544_0# a_344_n36# a_268_0# w_n62_n62# sg13_lv_pmos ad=0.76p pd=4.38u as=0.76p ps=4.38u w=4u l=1u
X5 a_2200_0# a_2000_n36# a_1924_0# w_n62_n62# sg13_lv_pmos ad=0.76p pd=4.38u as=0.76p ps=4.38u w=4u l=1u
X6 a_3580_0# a_3380_n36# a_3304_0# w_n62_n62# sg13_lv_pmos ad=0.76p pd=4.38u as=0.76p ps=4.38u w=4u l=1u
X7 a_6340_0# a_6140_n36# a_6064_0# w_n62_n62# sg13_lv_pmos ad=0.76p pd=4.38u as=0.76p ps=4.38u w=4u l=1u
X8 a_1096_0# a_896_n36# a_820_0# w_n62_n62# sg13_lv_pmos ad=0.76p pd=4.38u as=0.76p ps=4.38u w=4u l=1u
X9 a_2752_0# a_2552_n36# a_2476_0# w_n62_n62# sg13_lv_pmos ad=0.76p pd=4.38u as=0.76p ps=4.38u w=4u l=1u
X10 a_5512_0# a_5312_n36# a_5236_0# w_n62_n62# sg13_lv_pmos ad=0.76p pd=4.38u as=0.76p ps=4.38u w=4u l=1u
X11 a_6892_0# a_6692_n36# a_6616_0# w_n62_n62# sg13_lv_pmos ad=1.36p pd=8.68u as=0.76p ps=4.38u w=4u l=1u
X12 a_1924_0# a_1724_n36# a_1648_0# w_n62_n62# sg13_lv_pmos ad=0.76p pd=4.38u as=0.76p ps=4.38u w=4u l=1u
X13 a_6064_0# a_5864_n36# a_5788_0# w_n62_n62# sg13_lv_pmos ad=0.76p pd=4.38u as=0.76p ps=4.38u w=4u l=1u
X14 a_2476_0# a_2276_n36# a_2200_0# w_n62_n62# sg13_lv_pmos ad=0.76p pd=4.38u as=0.76p ps=4.38u w=4u l=1u
X15 a_5236_0# a_5036_n36# a_4960_0# w_n62_n62# sg13_lv_pmos ad=0.76p pd=4.38u as=0.76p ps=4.38u w=4u l=1u
X16 a_1648_0# a_1448_n36# a_1372_0# w_n62_n62# sg13_lv_pmos ad=0.76p pd=4.38u as=0.76p ps=4.38u w=4u l=1u
X17 a_4408_0# a_4208_n36# a_4132_0# w_n62_n62# sg13_lv_pmos ad=0.76p pd=4.38u as=0.76p ps=4.38u w=4u l=1u
X18 a_5788_0# a_5588_n36# a_5512_0# w_n62_n62# sg13_lv_pmos ad=0.76p pd=4.38u as=0.76p ps=4.38u w=4u l=1u
X19 a_4960_0# a_4760_n36# a_4684_0# w_n62_n62# sg13_lv_pmos ad=0.76p pd=4.38u as=0.76p ps=4.38u w=4u l=1u
X20 a_268_0# a_68_n36# a_0_0# w_n62_n62# sg13_lv_pmos ad=0.76p pd=4.38u as=1.36p ps=8.68u w=4u l=1u
X21 a_1372_0# a_1172_n36# a_1096_0# w_n62_n62# sg13_lv_pmos ad=0.76p pd=4.38u as=0.76p ps=4.38u w=4u l=1u
X22 a_4132_0# a_3932_n36# a_3856_0# w_n62_n62# sg13_lv_pmos ad=0.76p pd=4.38u as=0.76p ps=4.38u w=4u l=1u
X23 a_3304_0# a_3104_n36# a_3028_0# w_n62_n62# sg13_lv_pmos ad=0.76p pd=4.38u as=0.76p ps=4.38u w=4u l=1u
X24 a_4684_0# a_4484_n36# a_4408_0# w_n62_n62# sg13_lv_pmos ad=0.76p pd=4.38u as=0.76p ps=4.38u w=4u l=1u
C0 w_n62_n62# a_1372_0# 0.06444f
C1 a_544_0# a_820_0# 0.10853f
C2 a_4484_n36# a_4684_0# 0.11057f
C3 a_544_0# a_620_n36# 0.11057f
C4 a_6616_0# a_6892_0# 0.10853f
C5 a_6416_n36# a_6692_n36# 0.01172f
C6 a_1724_n36# a_1648_0# 0.11057f
C7 w_n62_n62# a_4760_n36# 0.40586f
C8 a_6064_0# a_5864_n36# 0.11057f
C9 a_4208_n36# a_3932_n36# 0.01172f
C10 a_5036_n36# a_4960_0# 0.11057f
C11 a_4484_n36# a_4208_n36# 0.01172f
C12 w_n62_n62# a_4408_0# 0.06444f
C13 a_5236_0# a_5512_0# 0.10853f
C14 a_2200_0# w_n62_n62# 0.06444f
C15 a_3104_n36# a_2828_n36# 0.01172f
C16 a_896_n36# a_820_0# 0.11057f
C17 w_n62_n62# a_3856_0# 0.06444f
C18 a_68_n36# a_268_0# 0.11057f
C19 a_620_n36# a_896_n36# 0.01172f
C20 a_6064_0# a_5788_0# 0.10853f
C21 a_4208_n36# a_4132_0# 0.11057f
C22 a_3304_0# w_n62_n62# 0.06444f
C23 w_n62_n62# a_5864_n36# 0.40586f
C24 a_3932_n36# a_4132_0# 0.11057f
C25 a_3104_n36# a_3028_0# 0.11057f
C26 a_2552_n36# a_2752_0# 0.11057f
C27 w_n62_n62# a_0_0# 0.05653f
C28 a_1648_0# a_1372_0# 0.10853f
C29 a_1172_n36# a_1372_0# 0.11057f
C30 a_6340_0# a_6616_0# 0.10853f
C31 a_4760_n36# a_5036_n36# 0.01172f
C32 a_5312_n36# a_5512_0# 0.11057f
C33 a_2000_n36# a_1724_n36# 0.01172f
C34 w_n62_n62# a_5036_n36# 0.40586f
C35 w_n62_n62# a_5788_0# 0.06444f
C36 a_4960_0# a_5236_0# 0.10853f
C37 a_2000_n36# a_2276_n36# 0.01172f
C38 a_1648_0# w_n62_n62# 0.06444f
C39 w_n62_n62# a_1172_n36# 0.40586f
C40 a_344_n36# a_620_n36# 0.01172f
C41 a_6892_0# w_n62_n62# 0.05653f
C42 a_2752_0# w_n62_n62# 0.06444f
C43 a_6064_0# a_6140_n36# 0.11057f
C44 a_6616_0# a_6692_n36# 0.11057f
C45 a_3380_n36# w_n62_n62# 0.40586f
C46 a_3028_0# a_2828_n36# 0.11057f
C47 a_5588_n36# a_5512_0# 0.11057f
C48 a_5864_n36# a_5788_0# 0.11057f
C49 a_3656_n36# w_n62_n62# 0.40586f
C50 a_6064_0# a_6340_0# 0.10853f
C51 a_1096_0# a_896_n36# 0.11057f
C52 a_544_0# a_268_0# 0.10853f
C53 a_3380_n36# a_3304_0# 0.11057f
C54 a_3656_n36# a_3856_0# 0.11057f
C55 a_6616_0# a_6416_n36# 0.11057f
C56 w_n62_n62# a_5236_0# 0.06444f
C57 w_n62_n62# a_820_0# 0.06444f
C58 a_6140_n36# w_n62_n62# 0.40586f
C59 a_4684_0# a_4960_0# 0.10853f
C60 a_68_n36# a_344_n36# 0.01172f
C61 w_n62_n62# a_620_n36# 0.40586f
C62 a_2000_n36# w_n62_n62# 0.40586f
C63 a_2000_n36# a_2200_0# 0.11057f
C64 a_6340_0# w_n62_n62# 0.06444f
C65 a_6140_n36# a_5864_n36# 0.01172f
C66 w_n62_n62# a_5312_n36# 0.40586f
C67 a_2276_n36# a_2476_0# 0.11057f
C68 a_1724_n36# a_1924_0# 0.11057f
C69 a_4760_n36# a_4684_0# 0.11057f
C70 a_5036_n36# a_5236_0# 0.11057f
C71 a_2552_n36# a_2476_0# 0.11057f
C72 w_n62_n62# a_68_n36# 0.40854f
C73 a_1096_0# a_1372_0# 0.10853f
C74 w_n62_n62# a_4684_0# 0.06444f
C75 a_4408_0# a_4684_0# 0.10853f
C76 a_6692_n36# w_n62_n62# 0.40854f
C77 a_3104_n36# w_n62_n62# 0.40586f
C78 a_3380_n36# a_3656_n36# 0.01172f
C79 a_2552_n36# a_2828_n36# 0.01172f
C80 a_4484_n36# a_4760_n36# 0.01172f
C81 w_n62_n62# a_4208_n36# 0.40586f
C82 a_4208_n36# a_4408_0# 0.11057f
C83 a_344_n36# a_268_0# 0.11057f
C84 a_5588_n36# w_n62_n62# 0.40586f
C85 a_3580_0# w_n62_n62# 0.06444f
C86 w_n62_n62# a_3932_n36# 0.40586f
C87 a_4484_n36# w_n62_n62# 0.40586f
C88 a_1096_0# w_n62_n62# 0.06444f
C89 a_3104_n36# a_3304_0# 0.11057f
C90 a_4484_n36# a_4408_0# 0.11057f
C91 a_68_n36# a_0_0# 0.11057f
C92 a_5312_n36# a_5036_n36# 0.01172f
C93 a_6416_n36# w_n62_n62# 0.40586f
C94 a_544_0# a_344_n36# 0.11057f
C95 a_1724_n36# a_1448_n36# 0.01172f
C96 a_3580_0# a_3856_0# 0.10853f
C97 a_3932_n36# a_3856_0# 0.11057f
C98 a_2476_0# w_n62_n62# 0.06444f
C99 a_3304_0# a_3580_0# 0.10853f
C100 a_5588_n36# a_5864_n36# 0.01172f
C101 a_2476_0# a_2200_0# 0.10853f
C102 w_n62_n62# a_4132_0# 0.06444f
C103 a_4132_0# a_4408_0# 0.10853f
C104 w_n62_n62# a_2828_n36# 0.40586f
C105 a_1924_0# w_n62_n62# 0.06444f
C106 a_620_n36# a_820_0# 0.11057f
C107 a_3856_0# a_4132_0# 0.10853f
C108 w_n62_n62# a_268_0# 0.06444f
C109 a_1924_0# a_2200_0# 0.10853f
C110 a_6340_0# a_6140_n36# 0.11057f
C111 a_3028_0# w_n62_n62# 0.06444f
C112 a_6892_0# a_6692_n36# 0.11057f
C113 a_1448_n36# a_1372_0# 0.11057f
C114 w_n62_n62# a_544_0# 0.06444f
C115 a_5588_n36# a_5788_0# 0.11057f
C116 a_3380_n36# a_3104_n36# 0.01172f
C117 a_1096_0# a_1172_n36# 0.11057f
C118 a_5312_n36# a_5236_0# 0.11057f
C119 a_0_0# a_268_0# 0.10853f
C120 a_3028_0# a_3304_0# 0.10853f
C121 a_3380_n36# a_3580_0# 0.11057f
C122 w_n62_n62# a_1448_n36# 0.40586f
C123 w_n62_n62# a_5512_0# 0.06444f
C124 a_2276_n36# a_2552_n36# 0.01172f
C125 a_3656_n36# a_3580_0# 0.11057f
C126 w_n62_n62# a_896_n36# 0.40586f
C127 a_3656_n36# a_3932_n36# 0.01172f
C128 a_2476_0# a_2752_0# 0.10853f
C129 a_1648_0# a_1924_0# 0.10853f
C130 a_6616_0# w_n62_n62# 0.06444f
C131 a_2752_0# a_2828_n36# 0.11057f
C132 a_1096_0# a_820_0# 0.10853f
C133 a_1724_n36# w_n62_n62# 0.40586f
C134 a_6416_n36# a_6140_n36# 0.01172f
C135 a_2752_0# a_3028_0# 0.10853f
C136 a_4760_n36# a_4960_0# 0.11057f
C137 a_2276_n36# w_n62_n62# 0.40586f
C138 a_6340_0# a_6416_n36# 0.11057f
C139 w_n62_n62# a_4960_0# 0.06444f
C140 a_2276_n36# a_2200_0# 0.11057f
C141 a_5512_0# a_5788_0# 0.10853f
C142 a_2552_n36# w_n62_n62# 0.40586f
C143 a_1648_0# a_1448_n36# 0.11057f
C144 w_n62_n62# a_344_n36# 0.40586f
C145 a_5588_n36# a_5312_n36# 0.01172f
C146 a_1172_n36# a_1448_n36# 0.01172f
C147 a_2000_n36# a_1924_0# 0.11057f
C148 a_6064_0# w_n62_n62# 0.06444f
C149 a_896_n36# a_1172_n36# 0.01172f
C150 a_6892_0# sub 0.14307f
C151 a_6616_0# sub 0.01094f
C152 a_6340_0# sub 0.01094f
C153 a_6064_0# sub 0.01094f
C154 a_5788_0# sub 0.01094f
C155 a_5512_0# sub 0.01094f
C156 a_5236_0# sub 0.01094f
C157 a_4960_0# sub 0.01094f
C158 a_4684_0# sub 0.01094f
C159 a_4408_0# sub 0.01094f
C160 a_4132_0# sub 0.01094f
C161 a_3856_0# sub 0.01094f
C162 a_3580_0# sub 0.01094f
C163 a_3304_0# sub 0.01094f
C164 a_3028_0# sub 0.01094f
C165 a_2752_0# sub 0.01094f
C166 a_2476_0# sub 0.01094f
C167 a_2200_0# sub 0.01094f
C168 a_1924_0# sub 0.01094f
C169 a_1648_0# sub 0.01094f
C170 a_1372_0# sub 0.01094f
C171 a_1096_0# sub 0.01094f
C172 a_820_0# sub 0.01094f
C173 a_544_0# sub 0.01094f
C174 a_268_0# sub 0.01094f
C175 a_0_0# sub 0.14307f
C176 a_6692_n36# sub 0.08376f
C177 a_6416_n36# sub 0.0764f
C178 a_6140_n36# sub 0.0764f
C179 a_5864_n36# sub 0.0764f
C180 a_5588_n36# sub 0.0764f
C181 a_5312_n36# sub 0.0764f
C182 a_5036_n36# sub 0.0764f
C183 a_4760_n36# sub 0.0764f
C184 a_4484_n36# sub 0.0764f
C185 a_4208_n36# sub 0.0764f
C186 a_3932_n36# sub 0.0764f
C187 a_3656_n36# sub 0.0764f
C188 a_3380_n36# sub 0.0764f
C189 a_3104_n36# sub 0.0764f
C190 a_2828_n36# sub 0.0764f
C191 a_2552_n36# sub 0.0764f
C192 a_2276_n36# sub 0.0764f
C193 a_2000_n36# sub 0.0764f
C194 a_1724_n36# sub 0.0764f
C195 a_1448_n36# sub 0.0764f
C196 a_1172_n36# sub 0.0764f
C197 a_896_n36# sub 0.0764f
C198 a_620_n36# sub 0.0764f
C199 a_344_n36# sub 0.0764f
C200 a_68_n36# sub 0.08376f
.ends

.subckt pc_nmos_8 a_222_n21# a_430_15# a_282_15# a_134_15# a_74_n21# a_518_n21# a_370_n21#  sub a_814_n21# a_666_n21# a_874_15# a_1110_n21# a_726_15# a_578_15# a_0_0# a_962_n21#  a_1170_15# a_1022_15#
X0 a_1170_15# a_1110_n21# a_1022_15# sub sg13_lv_nmos ad=0.1005p pd=1.34u as=55.5f ps=0.74u w=0.15u l=0.3u
X1 a_726_15# a_666_n21# a_578_15# sub sg13_lv_nmos ad=55.5f pd=0.74u as=55.5f ps=0.74u w=0.15u l=0.3u
X2 a_134_15# a_74_n21# a_0_0# sub sg13_lv_nmos ad=55.5f pd=0.74u as=0.1005p ps=1.34u w=0.15u l=0.3u
X3 a_430_15# a_370_n21# a_282_15# sub sg13_lv_nmos ad=55.5f pd=0.74u as=55.5f ps=0.74u w=0.15u l=0.3u
X4 a_578_15# a_518_n21# a_430_15# sub sg13_lv_nmos ad=55.5f pd=0.74u as=55.5f ps=0.74u w=0.15u l=0.3u
X5 a_1022_15# a_962_n21# a_874_15# sub sg13_lv_nmos ad=55.5f pd=0.74u as=55.5f ps=0.74u w=0.15u l=0.3u
X6 a_282_15# a_222_n21# a_134_15# sub sg13_lv_nmos ad=55.5f pd=0.74u as=55.5f ps=0.74u w=0.15u l=0.3u
X7 a_874_15# a_814_n21# a_726_15# sub sg13_lv_nmos ad=55.5f pd=0.74u as=55.5f ps=0.74u w=0.15u l=0.3u
C0 a_814_n21# a_962_n21# 0.01005f
C1 a_1110_n21# a_962_n21# 0.01005f
C2 a_726_15# a_578_15# 0.01549f
C3 a_1022_15# a_874_15# 0.01549f
C4 a_1170_15# a_1022_15# 0.01549f
C5 a_578_15# a_430_15# 0.01549f
C6 a_518_n21# a_666_n21# 0.01005f
C7 a_222_n21# a_74_n21# 0.01005f
C8 a_814_n21# a_666_n21# 0.01005f
C9 a_222_n21# a_370_n21# 0.01005f
C10 a_370_n21# a_518_n21# 0.01005f
C11 a_726_15# a_874_15# 0.01549f
C12 a_134_15# a_0_0# 0.01549f
C13 a_134_15# a_282_15# 0.01549f
C14 a_282_15# a_430_15# 0.01549f
C15 a_1170_15# sub 0.02278f
C16 a_1110_n21# sub 0.06283f
C17 a_1022_15# sub 0.01307f
C18 a_962_n21# sub 0.05349f
C19 a_874_15# sub 0.01307f
C20 a_814_n21# sub 0.05349f
C21 a_726_15# sub 0.01307f
C22 a_666_n21# sub 0.05349f
C23 a_578_15# sub 0.01307f
C24 a_518_n21# sub 0.05349f
C25 a_430_15# sub 0.01307f
C26 a_370_n21# sub 0.05349f
C27 a_282_15# sub 0.01307f
C28 a_222_n21# sub 0.05349f
C29 a_134_15# sub 0.01307f
C30 a_74_n21# sub 0.06283f
C31 a_0_0# sub 0.02278f
.ends

.subckt pc_pmos_3 a_2354_n21# a_1582_15# a_1556_n21# a_442_15# a_2722_15# a_1670_n21#  a_1240_15# a_100_15# a_758_n21# a_2468_n21# a_872_n21# a_2582_n21# a_2380_15# a_1784_n21#  a_1468_15# a_986_n21# a_328_15# a_2696_n21# a_2608_15# a_1898_n21# a_1126_15# w_n62_n62#  a_188_n21# a_74_n21# a_2266_15# a_1810_15# a_670_15# sub a_898_15# a_1696_15# a_556_15#  a_2836_15# a_1354_15# a_214_15# a_1012_15# a_2494_15# a_1100_n21# a_2810_n21# a_2152_15#  a_302_n21# a_2012_n21# a_1214_n21# a_0_0# a_416_n21# a_2126_n21# a_1924_15# a_1328_n21#  a_530_n21# a_2240_n21# a_1442_n21# a_2038_15# a_784_15# a_644_n21#
X0 a_2380_15# a_2354_n21# a_2266_15# w_n62_n62# sg13_lv_pmos ad=55.5f pd=0.74u as=55.5f ps=0.74u w=0.15u l=0.13u
X1 a_670_15# a_644_n21# a_556_15# w_n62_n62# sg13_lv_pmos ad=55.5f pd=0.74u as=55.5f ps=0.74u w=0.15u l=0.13u
X2 a_1696_15# a_1670_n21# a_1582_15# w_n62_n62# sg13_lv_pmos ad=55.5f pd=0.74u as=55.5f ps=0.74u w=0.15u l=0.13u
X3 a_1126_15# a_1100_n21# a_1012_15# w_n62_n62# sg13_lv_pmos ad=55.5f pd=0.74u as=55.5f ps=0.74u w=0.15u l=0.13u
X4 a_2608_15# a_2582_n21# a_2494_15# w_n62_n62# sg13_lv_pmos ad=55.5f pd=0.74u as=55.5f ps=0.74u w=0.15u l=0.13u
X5 a_898_15# a_872_n21# a_784_15# w_n62_n62# sg13_lv_pmos ad=55.5f pd=0.74u as=55.5f ps=0.74u w=0.15u l=0.13u
X6 a_2038_15# a_2012_n21# a_1924_15# w_n62_n62# sg13_lv_pmos ad=55.5f pd=0.74u as=55.5f ps=0.74u w=0.15u l=0.13u
X7 a_328_15# a_302_n21# a_214_15# w_n62_n62# sg13_lv_pmos ad=55.5f pd=0.74u as=55.5f ps=0.74u w=0.15u l=0.13u
X8 a_2836_15# a_2810_n21# a_2722_15# w_n62_n62# sg13_lv_pmos ad=0.1005p pd=1.34u as=55.5f ps=0.74u w=0.15u l=0.13u
X9 a_2266_15# a_2240_n21# a_2152_15# w_n62_n62# sg13_lv_pmos ad=55.5f pd=0.74u as=55.5f ps=0.74u w=0.15u l=0.13u
X10 a_556_15# a_530_n21# a_442_15# w_n62_n62# sg13_lv_pmos ad=55.5f pd=0.74u as=55.5f ps=0.74u w=0.15u l=0.13u
X11 a_100_15# a_74_n21# a_0_0# w_n62_n62# sg13_lv_pmos ad=55.5f pd=0.74u as=0.1005p ps=1.34u w=0.15u l=0.13u
X12 a_1924_15# a_1898_n21# a_1810_15# w_n62_n62# sg13_lv_pmos ad=55.5f pd=0.74u as=55.5f ps=0.74u w=0.15u l=0.13u
X13 a_1354_15# a_1328_n21# a_1240_15# w_n62_n62# sg13_lv_pmos ad=55.5f pd=0.74u as=55.5f ps=0.74u w=0.15u l=0.13u
X14 a_1582_15# a_1556_n21# a_1468_15# w_n62_n62# sg13_lv_pmos ad=55.5f pd=0.74u as=55.5f ps=0.74u w=0.15u l=0.13u
X15 a_2494_15# a_2468_n21# a_2380_15# w_n62_n62# sg13_lv_pmos ad=55.5f pd=0.74u as=55.5f ps=0.74u w=0.15u l=0.13u
X16 a_784_15# a_758_n21# a_670_15# w_n62_n62# sg13_lv_pmos ad=55.5f pd=0.74u as=55.5f ps=0.74u w=0.15u l=0.13u
X17 a_1810_15# a_1784_n21# a_1696_15# w_n62_n62# sg13_lv_pmos ad=55.5f pd=0.74u as=55.5f ps=0.74u w=0.15u l=0.13u
X18 a_1240_15# a_1214_n21# a_1126_15# w_n62_n62# sg13_lv_pmos ad=55.5f pd=0.74u as=55.5f ps=0.74u w=0.15u l=0.13u
X19 a_214_15# a_188_n21# a_100_15# w_n62_n62# sg13_lv_pmos ad=55.5f pd=0.74u as=55.5f ps=0.74u w=0.15u l=0.13u
X20 a_2722_15# a_2696_n21# a_2608_15# w_n62_n62# sg13_lv_pmos ad=55.5f pd=0.74u as=55.5f ps=0.74u w=0.15u l=0.13u
X21 a_1012_15# a_986_n21# a_898_15# w_n62_n62# sg13_lv_pmos ad=55.5f pd=0.74u as=55.5f ps=0.74u w=0.15u l=0.13u
X22 a_2152_15# a_2126_n21# a_2038_15# w_n62_n62# sg13_lv_pmos ad=55.5f pd=0.74u as=55.5f ps=0.74u w=0.15u l=0.13u
X23 a_442_15# a_416_n21# a_328_15# w_n62_n62# sg13_lv_pmos ad=55.5f pd=0.74u as=55.5f ps=0.74u w=0.15u l=0.13u
X24 a_1468_15# a_1442_n21# a_1354_15# w_n62_n62# sg13_lv_pmos ad=55.5f pd=0.74u as=55.5f ps=0.74u w=0.15u l=0.13u
C0 w_n62_n62# a_416_n21# 0.02172f
C1 a_872_n21# a_758_n21# 0.01005f
C2 a_670_15# a_784_15# 0.02238f
C3 a_898_15# a_1012_15# 0.02238f
C4 a_2582_n21# a_2696_n21# 0.01005f
C5 a_188_n21# a_74_n21# 0.01005f
C6 w_n62_n62# a_2012_n21# 0.02172f
C7 w_n62_n62# a_530_n21# 0.02172f
C8 a_2012_n21# a_2126_n21# 0.01005f
C9 a_556_15# a_442_15# 0.02238f
C10 a_2152_15# a_2266_15# 0.02238f
C11 w_n62_n62# a_644_n21# 0.02172f
C12 a_188_n21# a_302_n21# 0.01005f
C13 a_1328_n21# w_n62_n62# 0.02172f
C14 a_2582_n21# w_n62_n62# 0.02172f
C15 a_556_15# a_670_15# 0.02238f
C16 a_1240_15# a_1126_15# 0.02238f
C17 a_1100_n21# a_986_n21# 0.01005f
C18 a_1240_15# a_1354_15# 0.02238f
C19 w_n62_n62# a_2696_n21# 0.02172f
C20 a_1468_15# a_1582_15# 0.02238f
C21 a_1924_15# a_1810_15# 0.02238f
C22 a_2722_15# a_2836_15# 0.02238f
C23 a_644_n21# a_758_n21# 0.01005f
C24 w_n62_n62# a_986_n21# 0.02172f
C25 a_1328_n21# a_1442_n21# 0.01005f
C26 w_n62_n62# a_1898_n21# 0.02172f
C27 a_416_n21# a_302_n21# 0.01005f
C28 w_n62_n62# a_1556_n21# 0.02172f
C29 a_2354_n21# w_n62_n62# 0.02172f
C30 a_2038_15# a_2152_15# 0.02238f
C31 w_n62_n62# a_1100_n21# 0.02172f
C32 a_1784_n21# a_1898_n21# 0.01005f
C33 a_1328_n21# a_1214_n21# 0.01005f
C34 a_1582_15# a_1696_15# 0.02238f
C35 a_1556_n21# a_1670_n21# 0.01005f
C36 a_1012_15# a_1126_15# 0.02238f
C37 w_n62_n62# a_2126_n21# 0.02172f
C38 a_2380_15# a_2494_15# 0.02238f
C39 a_214_15# a_100_15# 0.02238f
C40 a_2608_15# a_2494_15# 0.02238f
C41 w_n62_n62# a_1784_n21# 0.02172f
C42 w_n62_n62# a_1670_n21# 0.02172f
C43 a_1556_n21# a_1442_n21# 0.01005f
C44 a_898_15# a_784_15# 0.02238f
C45 a_2468_n21# a_2582_n21# 0.01005f
C46 a_530_n21# a_416_n21# 0.01005f
C47 a_1784_n21# a_1670_n21# 0.01005f
C48 a_1468_15# a_1354_15# 0.02238f
C49 a_2266_15# a_2380_15# 0.02238f
C50 a_328_15# a_442_15# 0.02238f
C51 a_872_n21# a_986_n21# 0.01005f
C52 w_n62_n62# a_1442_n21# 0.02172f
C53 a_1214_n21# a_1100_n21# 0.01005f
C54 a_1810_15# a_1696_15# 0.02238f
C55 w_n62_n62# a_758_n21# 0.02172f
C56 a_644_n21# a_530_n21# 0.01005f
C57 a_2354_n21# a_2468_n21# 0.01005f
C58 a_2810_n21# a_2696_n21# 0.01005f
C59 w_n62_n62# a_1214_n21# 0.02172f
C60 w_n62_n62# a_74_n21# 0.02392f
C61 w_n62_n62# a_188_n21# 0.02172f
C62 a_0_0# a_100_15# 0.02238f
C63 w_n62_n62# a_872_n21# 0.02172f
C64 a_2608_15# a_2722_15# 0.02238f
C65 a_2468_n21# w_n62_n62# 0.02172f
C66 a_2354_n21# a_2240_n21# 0.01005f
C67 a_1924_15# a_2038_15# 0.02238f
C68 w_n62_n62# a_302_n21# 0.02172f
C69 w_n62_n62# a_2810_n21# 0.02392f
C70 w_n62_n62# a_2240_n21# 0.02172f
C71 a_328_15# a_214_15# 0.02238f
C72 a_2126_n21# a_2240_n21# 0.01005f
C73 a_2012_n21# a_1898_n21# 0.01005f
C74 a_2836_15# sub 0.01942f
C75 a_2810_n21# sub 0.01618f
C76 a_2722_15# sub 0.01084f
C77 a_2608_15# sub 0.01084f
C78 a_2494_15# sub 0.01084f
C79 a_2380_15# sub 0.01084f
C80 a_2266_15# sub 0.01084f
C81 a_2152_15# sub 0.01084f
C82 a_2038_15# sub 0.01084f
C83 a_1924_15# sub 0.01084f
C84 a_1810_15# sub 0.01084f
C85 a_1696_15# sub 0.01084f
C86 a_1582_15# sub 0.01084f
C87 a_1468_15# sub 0.01084f
C88 a_1354_15# sub 0.01084f
C89 a_1240_15# sub 0.01084f
C90 a_1126_15# sub 0.01084f
C91 a_1012_15# sub 0.01084f
C92 a_898_15# sub 0.01084f
C93 a_784_15# sub 0.01084f
C94 a_670_15# sub 0.01084f
C95 a_556_15# sub 0.01084f
C96 a_442_15# sub 0.01084f
C97 a_328_15# sub 0.01084f
C98 a_214_15# sub 0.01084f
C99 a_100_15# sub 0.01084f
C100 a_74_n21# sub 0.01618f
C101 a_0_0# sub 0.01942f
.ends

.subckt pc_nmos_6 a_944_0# a_1496_n36# a_1896_0# a_68_n36# a_3324_0# a_2372_0# a_3400_n36#  sub a_3800_0# a_2924_n36# a_1020_n36# a_2448_n36# a_468_0# a_1420_0# a_0_0# a_1972_n36#  a_544_n36# a_2848_0#
X0 a_2372_0# a_1972_n36# a_1896_0# sub sg13_lv_nmos ad=0.19p pd=1.38u as=0.19p ps=1.38u w=1u l=2u
X1 a_2848_0# a_2448_n36# a_2372_0# sub sg13_lv_nmos ad=0.19p pd=1.38u as=0.19p ps=1.38u w=1u l=2u
X2 a_1420_0# a_1020_n36# a_944_0# sub sg13_lv_nmos ad=0.19p pd=1.38u as=0.19p ps=1.38u w=1u l=2u
X3 a_3324_0# a_2924_n36# a_2848_0# sub sg13_lv_nmos ad=0.19p pd=1.38u as=0.19p ps=1.38u w=1u l=2u
X4 a_944_0# a_544_n36# a_468_0# sub sg13_lv_nmos ad=0.19p pd=1.38u as=0.19p ps=1.38u w=1u l=2u
X5 a_3800_0# a_3400_n36# a_3324_0# sub sg13_lv_nmos ad=0.34p pd=2.68u as=0.19p ps=1.38u w=1u l=2u
X6 a_468_0# a_68_n36# a_0_0# sub sg13_lv_nmos ad=0.19p pd=1.38u as=0.34p ps=2.68u w=1u l=2u
X7 a_1896_0# a_1496_n36# a_1420_0# sub sg13_lv_nmos ad=0.19p pd=1.38u as=0.19p ps=1.38u w=1u l=2u
C0 a_2848_0# a_3324_0# 0.01424f
C1 a_2924_n36# a_3400_n36# 0.01172f
C2 a_68_n36# a_468_0# 0.03479f
C3 a_3400_n36# a_3800_0# 0.03479f
C4 a_1020_n36# a_1420_0# 0.03479f
C5 a_1972_n36# a_2372_0# 0.03479f
C6 a_468_0# a_0_0# 0.01424f
C7 a_1896_0# a_1420_0# 0.01424f
C8 a_68_n36# a_0_0# 0.03479f
C9 a_544_n36# a_944_0# 0.03479f
C10 a_1496_n36# a_1020_n36# 0.01172f
C11 a_1496_n36# a_1420_0# 0.03479f
C12 a_2848_0# a_2372_0# 0.01424f
C13 a_1896_0# a_1496_n36# 0.03479f
C14 a_2924_n36# a_2848_0# 0.03479f
C15 a_3400_n36# a_3324_0# 0.03479f
C16 a_544_n36# a_468_0# 0.03479f
C17 a_68_n36# a_544_n36# 0.01172f
C18 a_2448_n36# a_2372_0# 0.03479f
C19 a_544_n36# a_1020_n36# 0.01172f
C20 a_468_0# a_944_0# 0.01424f
C21 a_2924_n36# a_2448_n36# 0.01172f
C22 a_1896_0# a_2372_0# 0.01424f
C23 a_2924_n36# a_3324_0# 0.03479f
C24 a_1020_n36# a_944_0# 0.03479f
C25 a_1972_n36# a_2448_n36# 0.01172f
C26 a_944_0# a_1420_0# 0.01424f
C27 a_3324_0# a_3800_0# 0.01424f
C28 a_1896_0# a_1972_n36# 0.03479f
C29 a_1496_n36# a_1972_n36# 0.01172f
C30 a_2448_n36# a_2848_0# 0.03479f
C31 a_3800_0# sub 0.05102f
C32 a_3324_0# sub 0.01267f
C33 a_2848_0# sub 0.01267f
C34 a_2372_0# sub 0.01267f
C35 a_1896_0# sub 0.01267f
C36 a_1420_0# sub 0.01267f
C37 a_944_0# sub 0.01267f
C38 a_468_0# sub 0.01267f
C39 a_0_0# sub 0.05102f
C40 a_3400_n36# sub 0.43798f
C41 a_2924_n36# sub 0.42794f
C42 a_2448_n36# sub 0.42794f
C43 a_1972_n36# sub 0.42794f
C44 a_1496_n36# sub 0.42794f
C45 a_1020_n36# sub 0.42794f
C46 a_544_n36# sub 0.42794f
C47 a_68_n36# sub 0.43798f
.ends

.subckt pc_pmos a_68_n36# w_n62_n62# sub a_168_0# a_0_0#
X0 a_168_0# a_68_n36# a_0_0# w_n62_n62# sg13_lv_pmos ad=0.85p pd=5.68u as=0.85p ps=5.68u w=2.5u l=0.5u
C0 a_0_0# a_68_n36# 0.04663f
C1 a_168_0# a_0_0# 0.11863f
C2 w_n62_n62# a_68_n36# 0.1487f
C3 a_168_0# w_n62_n62# 0.02959f
C4 a_168_0# a_68_n36# 0.04663f
C5 a_0_0# w_n62_n62# 0.02959f
C6 a_168_0# sub 0.09352f
C7 a_0_0# sub 0.09352f
C8 a_68_n36# sub 0.05293f
.ends

.subckt pc_pmos_1 a_4392_0# a_2280_0# a_5524_n36# a_3412_n36# a_1300_n36# a_4744_0# a_2632_0#  a_4116_n36# a_2708_n36# a_2004_n36# a_5272_0# a_3512_0# a_3160_0# a_1400_0# a_68_n36#  a_5624_0# a_344_0# a_4040_0# w_n62_n62# a_5172_n36# a_3764_n36# a_872_0# a_4468_n36#  a_3060_n36# a_1652_n36# a_2356_n36# a_948_n36# a_244_n36# a_4920_0# a_1048_0# sub  a_520_0# a_3688_0# a_1928_0# a_1576_0# a_3940_n36# a_4644_n36# a_2532_n36# a_596_n36#  a_4568_0# a_2456_0# a_5348_n36# a_3236_n36# a_1828_n36# a_2808_0# a_1124_n36# a_420_n36#  a_5096_0# a_5448_0# a_3336_0# a_1224_0# a_168_0# a_2984_0# a_0_0# a_4216_0# a_2104_0#  a_4996_n36# a_3864_0# a_1752_0# a_4292_n36# a_2884_n36# a_2180_n36# a_696_0# a_3588_n36#  a_1476_n36# a_4820_n36# a_772_n36#
X0 a_1048_0# a_948_n36# a_872_0# w_n62_n62# sg13_lv_pmos ad=0.475p pd=2.88u as=0.475p ps=2.88u w=2.5u l=0.5u
X1 a_1400_0# a_1300_n36# a_1224_0# w_n62_n62# sg13_lv_pmos ad=0.475p pd=2.88u as=0.475p ps=2.88u w=2.5u l=0.5u
X2 a_2808_0# a_2708_n36# a_2632_0# w_n62_n62# sg13_lv_pmos ad=0.475p pd=2.88u as=0.475p ps=2.88u w=2.5u l=0.5u
X3 a_4216_0# a_4116_n36# a_4040_0# w_n62_n62# sg13_lv_pmos ad=0.475p pd=2.88u as=0.475p ps=2.88u w=2.5u l=0.5u
X4 a_3512_0# a_3412_n36# a_3336_0# w_n62_n62# sg13_lv_pmos ad=0.475p pd=2.88u as=0.475p ps=2.88u w=2.5u l=0.5u
X5 a_5624_0# a_5524_n36# a_5448_0# w_n62_n62# sg13_lv_pmos ad=0.85p pd=5.68u as=0.475p ps=2.88u w=2.5u l=0.5u
X6 a_4920_0# a_4820_n36# a_4744_0# w_n62_n62# sg13_lv_pmos ad=0.475p pd=2.88u as=0.475p ps=2.88u w=2.5u l=0.5u
X7 a_1576_0# a_1476_n36# a_1400_0# w_n62_n62# sg13_lv_pmos ad=0.475p pd=2.88u as=0.475p ps=2.88u w=2.5u l=0.5u
X8 a_2280_0# a_2180_n36# a_2104_0# w_n62_n62# sg13_lv_pmos ad=0.475p pd=2.88u as=0.475p ps=2.88u w=2.5u l=0.5u
X9 a_3688_0# a_3588_n36# a_3512_0# w_n62_n62# sg13_lv_pmos ad=0.475p pd=2.88u as=0.475p ps=2.88u w=2.5u l=0.5u
X10 a_2984_0# a_2884_n36# a_2808_0# w_n62_n62# sg13_lv_pmos ad=0.475p pd=2.88u as=0.475p ps=2.88u w=2.5u l=0.5u
X11 a_4392_0# a_4292_n36# a_4216_0# w_n62_n62# sg13_lv_pmos ad=0.475p pd=2.88u as=0.475p ps=2.88u w=2.5u l=0.5u
X12 a_5096_0# a_4996_n36# a_4920_0# w_n62_n62# sg13_lv_pmos ad=0.475p pd=2.88u as=0.475p ps=2.88u w=2.5u l=0.5u
X13 a_1224_0# a_1124_n36# a_1048_0# w_n62_n62# sg13_lv_pmos ad=0.475p pd=2.88u as=0.475p ps=2.88u w=2.5u l=0.5u
X14 a_1928_0# a_1828_n36# a_1752_0# w_n62_n62# sg13_lv_pmos ad=0.475p pd=2.88u as=0.475p ps=2.88u w=2.5u l=0.5u
X15 a_3336_0# a_3236_n36# a_3160_0# w_n62_n62# sg13_lv_pmos ad=0.475p pd=2.88u as=0.475p ps=2.88u w=2.5u l=0.5u
X16 a_872_0# a_772_n36# a_696_0# w_n62_n62# sg13_lv_pmos ad=0.475p pd=2.88u as=0.475p ps=2.88u w=2.5u l=0.5u
X17 a_2632_0# a_2532_n36# a_2456_0# w_n62_n62# sg13_lv_pmos ad=0.475p pd=2.88u as=0.475p ps=2.88u w=2.5u l=0.5u
X18 a_5448_0# a_5348_n36# a_5272_0# w_n62_n62# sg13_lv_pmos ad=0.475p pd=2.88u as=0.475p ps=2.88u w=2.5u l=0.5u
X19 a_4040_0# a_3940_n36# a_3864_0# w_n62_n62# sg13_lv_pmos ad=0.475p pd=2.88u as=0.475p ps=2.88u w=2.5u l=0.5u
X20 a_4744_0# a_4644_n36# a_4568_0# w_n62_n62# sg13_lv_pmos ad=0.475p pd=2.88u as=0.475p ps=2.88u w=2.5u l=0.5u
X21 a_520_0# a_420_n36# a_344_0# w_n62_n62# sg13_lv_pmos ad=0.475p pd=2.88u as=0.475p ps=2.88u w=2.5u l=0.5u
X22 a_696_0# a_596_n36# a_520_0# w_n62_n62# sg13_lv_pmos ad=0.475p pd=2.88u as=0.475p ps=2.88u w=2.5u l=0.5u
X23 a_2456_0# a_2356_n36# a_2280_0# w_n62_n62# sg13_lv_pmos ad=0.475p pd=2.88u as=0.475p ps=2.88u w=2.5u l=0.5u
X24 a_4568_0# a_4468_n36# a_4392_0# w_n62_n62# sg13_lv_pmos ad=0.475p pd=2.88u as=0.475p ps=2.88u w=2.5u l=0.5u
X25 a_168_0# a_68_n36# a_0_0# w_n62_n62# sg13_lv_pmos ad=0.475p pd=2.88u as=0.85p ps=5.68u w=2.5u l=0.5u
X26 a_1752_0# a_1652_n36# a_1576_0# w_n62_n62# sg13_lv_pmos ad=0.475p pd=2.88u as=0.475p ps=2.88u w=2.5u l=0.5u
X27 a_3160_0# a_3060_n36# a_2984_0# w_n62_n62# sg13_lv_pmos ad=0.475p pd=2.88u as=0.475p ps=2.88u w=2.5u l=0.5u
X28 a_3864_0# a_3764_n36# a_3688_0# w_n62_n62# sg13_lv_pmos ad=0.475p pd=2.88u as=0.475p ps=2.88u w=2.5u l=0.5u
X29 a_5272_0# a_5172_n36# a_5096_0# w_n62_n62# sg13_lv_pmos ad=0.475p pd=2.88u as=0.475p ps=2.88u w=2.5u l=0.5u
X30 a_344_0# a_244_n36# a_168_0# w_n62_n62# sg13_lv_pmos ad=0.475p pd=2.88u as=0.475p ps=2.88u w=2.5u l=0.5u
X31 a_2104_0# a_2004_n36# a_1928_0# w_n62_n62# sg13_lv_pmos ad=0.475p pd=2.88u as=0.475p ps=2.88u w=2.5u l=0.5u
C0 a_4744_0# a_4644_n36# 0.04663f
C1 a_3336_0# a_3236_n36# 0.04663f
C2 a_2532_n36# w_n62_n62# 0.14334f
C3 a_5272_0# a_5448_0# 0.11863f
C4 a_4216_0# a_4392_0# 0.11863f
C5 a_1576_0# a_1752_0# 0.11863f
C6 a_4040_0# w_n62_n62# 0.02809f
C7 a_2280_0# a_2104_0# 0.11863f
C8 a_3412_n36# a_3512_0# 0.04663f
C9 a_420_n36# a_596_n36# 0.01172f
C10 a_3412_n36# a_3588_n36# 0.01172f
C11 a_1752_0# w_n62_n62# 0.02809f
C12 a_4116_n36# a_3940_n36# 0.01172f
C13 a_4920_0# w_n62_n62# 0.02809f
C14 a_2180_n36# w_n62_n62# 0.14334f
C15 a_2808_0# a_2984_0# 0.11863f
C16 a_3512_0# w_n62_n62# 0.02809f
C17 a_772_n36# w_n62_n62# 0.14334f
C18 a_1476_n36# a_1300_n36# 0.01172f
C19 a_1576_0# a_1652_n36# 0.04663f
C20 a_3060_n36# w_n62_n62# 0.14334f
C21 a_3688_0# w_n62_n62# 0.02809f
C22 a_520_0# a_420_n36# 0.04663f
C23 a_772_n36# a_948_n36# 0.01172f
C24 a_1048_0# a_1124_n36# 0.04663f
C25 a_2280_0# a_2356_n36# 0.04663f
C26 a_3588_n36# w_n62_n62# 0.14334f
C27 a_344_0# w_n62_n62# 0.02809f
C28 a_772_n36# a_872_0# 0.04663f
C29 a_244_n36# a_68_n36# 0.01172f
C30 a_5096_0# a_5272_0# 0.11863f
C31 a_4040_0# a_4216_0# 0.11863f
C32 a_244_n36# a_168_0# 0.04663f
C33 a_3940_n36# w_n62_n62# 0.14334f
C34 a_1652_n36# w_n62_n62# 0.14334f
C35 a_4920_0# a_4996_n36# 0.04663f
C36 a_1400_0# a_1476_n36# 0.04663f
C37 w_n62_n62# a_5172_n36# 0.14334f
C38 a_420_n36# a_244_n36# 0.01172f
C39 w_n62_n62# a_0_0# 0.02959f
C40 a_4116_n36# w_n62_n62# 0.14334f
C41 a_1124_n36# w_n62_n62# 0.14334f
C42 a_1828_n36# a_1928_0# 0.04663f
C43 a_2884_n36# a_2984_0# 0.04663f
C44 a_4920_0# a_4820_n36# 0.04663f
C45 a_3412_n36# w_n62_n62# 0.14334f
C46 a_3336_0# a_3160_0# 0.11863f
C47 a_2004_n36# a_1928_0# 0.04663f
C48 a_1124_n36# a_948_n36# 0.01172f
C49 a_4392_0# a_4292_n36# 0.04663f
C50 a_1576_0# w_n62_n62# 0.02809f
C51 a_1048_0# w_n62_n62# 0.02809f
C52 a_1300_n36# a_1224_0# 0.04663f
C53 a_2532_n36# a_2708_n36# 0.01172f
C54 a_2104_0# a_1928_0# 0.11863f
C55 a_3864_0# a_4040_0# 0.11863f
C56 a_4568_0# a_4468_n36# 0.04663f
C57 a_1048_0# a_948_n36# 0.04663f
C58 a_5524_n36# a_5348_n36# 0.01172f
C59 a_4468_n36# w_n62_n62# 0.14334f
C60 a_1048_0# a_872_0# 0.11863f
C61 a_4920_0# a_5096_0# 0.11863f
C62 a_4568_0# w_n62_n62# 0.02809f
C63 a_5172_n36# a_4996_n36# 0.01172f
C64 a_5524_n36# a_5624_0# 0.04663f
C65 a_2456_0# a_2632_0# 0.11863f
C66 a_1400_0# a_1224_0# 0.11863f
C67 a_3688_0# a_3764_n36# 0.04663f
C68 a_2532_n36# a_2632_0# 0.04663f
C69 a_948_n36# w_n62_n62# 0.14334f
C70 a_4116_n36# a_4216_0# 0.04663f
C71 a_344_0# a_168_0# 0.11863f
C72 a_3764_n36# a_3588_n36# 0.01172f
C73 w_n62_n62# a_872_0# 0.02809f
C74 a_3512_0# a_3336_0# 0.11863f
C75 a_2280_0# a_2456_0# 0.11863f
C76 a_1828_n36# a_1752_0# 0.04663f
C77 a_5448_0# w_n62_n62# 0.02809f
C78 a_948_n36# a_872_0# 0.04663f
C79 a_3764_n36# a_3940_n36# 0.01172f
C80 a_344_0# a_420_n36# 0.04663f
C81 a_68_n36# a_0_0# 0.04663f
C82 a_3688_0# a_3864_0# 0.11863f
C83 a_520_0# a_596_n36# 0.04663f
C84 a_2884_n36# a_3060_n36# 0.01172f
C85 a_168_0# a_0_0# 0.11863f
C86 a_2180_n36# a_2004_n36# 0.01172f
C87 a_5096_0# a_5172_n36# 0.04663f
C88 a_5272_0# a_5348_n36# 0.04663f
C89 w_n62_n62# a_4996_n36# 0.14334f
C90 a_1400_0# a_1300_n36# 0.04663f
C91 a_696_0# a_596_n36# 0.04663f
C92 a_2104_0# a_2180_n36# 0.04663f
C93 a_3864_0# a_3940_n36# 0.04663f
C94 a_4820_n36# w_n62_n62# 0.14334f
C95 a_4216_0# w_n62_n62# 0.02809f
C96 a_3412_n36# a_3336_0# 0.04663f
C97 a_2280_0# a_2180_n36# 0.04663f
C98 a_3160_0# a_3236_n36# 0.04663f
C99 a_2808_0# w_n62_n62# 0.02809f
C100 a_2456_0# a_2356_n36# 0.04663f
C101 a_2532_n36# a_2356_n36# 0.01172f
C102 a_1652_n36# a_1476_n36# 0.01172f
C103 a_1828_n36# a_1652_n36# 0.01172f
C104 w_n62_n62# a_68_n36# 0.14602f
C105 a_168_0# w_n62_n62# 0.02809f
C106 a_3764_n36# w_n62_n62# 0.14334f
C107 a_4744_0# a_4920_0# 0.11863f
C108 a_5096_0# w_n62_n62# 0.02809f
C109 a_1576_0# a_1476_n36# 0.04663f
C110 a_520_0# a_696_0# 0.11863f
C111 a_3336_0# w_n62_n62# 0.02809f
C112 a_420_n36# w_n62_n62# 0.14334f
C113 a_4820_n36# a_4996_n36# 0.01172f
C114 a_2708_n36# w_n62_n62# 0.14334f
C115 a_4644_n36# a_4468_n36# 0.01172f
C116 a_2180_n36# a_2356_n36# 0.01172f
C117 a_3864_0# w_n62_n62# 0.02809f
C118 a_4116_n36# a_4292_n36# 0.01172f
C119 a_4568_0# a_4644_n36# 0.04663f
C120 a_2884_n36# w_n62_n62# 0.14334f
C121 a_4644_n36# w_n62_n62# 0.14334f
C122 a_3060_n36# a_3236_n36# 0.01172f
C123 a_772_n36# a_596_n36# 0.01172f
C124 a_1476_n36# w_n62_n62# 0.14334f
C125 a_1828_n36# w_n62_n62# 0.14334f
C126 a_5096_0# a_4996_n36# 0.04663f
C127 w_n62_n62# a_2004_n36# 0.14334f
C128 a_3160_0# a_2984_0# 0.11863f
C129 a_1124_n36# a_1224_0# 0.04663f
C130 w_n62_n62# a_2632_0# 0.02809f
C131 a_4292_n36# a_4468_n36# 0.01172f
C132 a_2104_0# w_n62_n62# 0.02809f
C133 a_5172_n36# a_5348_n36# 0.01172f
C134 a_1048_0# a_1224_0# 0.11863f
C135 a_2280_0# w_n62_n62# 0.02809f
C136 a_4292_n36# w_n62_n62# 0.14334f
C137 a_168_0# a_68_n36# 0.04663f
C138 a_1752_0# a_1928_0# 0.11863f
C139 a_3412_n36# a_3236_n36# 0.01172f
C140 a_2532_n36# a_2456_0# 0.04663f
C141 a_2708_n36# a_2808_0# 0.04663f
C142 a_4644_n36# a_4820_n36# 0.01172f
C143 a_1124_n36# a_1300_n36# 0.01172f
C144 a_2884_n36# a_2808_0# 0.04663f
C145 a_4568_0# a_4744_0# 0.11863f
C146 w_n62_n62# a_1224_0# 0.02809f
C147 a_4744_0# w_n62_n62# 0.02809f
C148 a_696_0# a_772_n36# 0.04663f
C149 a_520_0# a_344_0# 0.11863f
C150 a_3864_0# a_3764_n36# 0.04663f
C151 a_3060_n36# a_2984_0# 0.04663f
C152 w_n62_n62# a_3236_n36# 0.14334f
C153 w_n62_n62# a_5348_n36# 0.14334f
C154 a_2356_n36# w_n62_n62# 0.14334f
C155 a_2808_0# a_2632_0# 0.11863f
C156 a_596_n36# w_n62_n62# 0.14334f
C157 a_5624_0# w_n62_n62# 0.02959f
C158 a_344_0# a_244_n36# 0.04663f
C159 a_4216_0# a_4292_n36# 0.04663f
C160 a_3060_n36# a_3160_0# 0.04663f
C161 a_5524_n36# w_n62_n62# 0.14602f
C162 a_2708_n36# a_2884_n36# 0.01172f
C163 a_1300_n36# w_n62_n62# 0.14334f
C164 a_1576_0# a_1400_0# 0.11863f
C165 a_5272_0# a_5172_n36# 0.04663f
C166 a_5448_0# a_5348_n36# 0.04663f
C167 a_4392_0# a_4468_n36# 0.04663f
C168 a_4744_0# a_4820_n36# 0.04663f
C169 a_5448_0# a_5624_0# 0.11863f
C170 a_4392_0# a_4568_0# 0.11863f
C171 a_2708_n36# a_2632_0# 0.04663f
C172 a_4392_0# w_n62_n62# 0.02809f
C173 a_5524_n36# a_5448_0# 0.04663f
C174 a_4040_0# a_3940_n36# 0.04663f
C175 a_1400_0# w_n62_n62# 0.02809f
C176 a_520_0# w_n62_n62# 0.02809f
C177 a_4116_n36# a_4040_0# 0.04663f
C178 w_n62_n62# a_1928_0# 0.02809f
C179 a_1828_n36# a_2004_n36# 0.01172f
C180 a_3688_0# a_3512_0# 0.11863f
C181 a_696_0# w_n62_n62# 0.02809f
C182 a_5272_0# w_n62_n62# 0.02809f
C183 w_n62_n62# a_2984_0# 0.02809f
C184 a_3512_0# a_3588_n36# 0.04663f
C185 a_1652_n36# a_1752_0# 0.04663f
C186 a_2104_0# a_2004_n36# 0.04663f
C187 a_3688_0# a_3588_n36# 0.04663f
C188 a_244_n36# w_n62_n62# 0.14334f
C189 a_696_0# a_872_0# 0.11863f
C190 a_3160_0# w_n62_n62# 0.02809f
C191 a_2456_0# w_n62_n62# 0.02809f
C192 a_5624_0# sub 0.09352f
C193 a_5448_0# sub 0.01094f
C194 a_5272_0# sub 0.01094f
C195 a_5096_0# sub 0.01094f
C196 a_4920_0# sub 0.01094f
C197 a_4744_0# sub 0.01094f
C198 a_4568_0# sub 0.01094f
C199 a_4392_0# sub 0.01094f
C200 a_4216_0# sub 0.01094f
C201 a_4040_0# sub 0.01094f
C202 a_3864_0# sub 0.01094f
C203 a_3688_0# sub 0.01094f
C204 a_3512_0# sub 0.01094f
C205 a_3336_0# sub 0.01094f
C206 a_3160_0# sub 0.01094f
C207 a_2984_0# sub 0.01094f
C208 a_2808_0# sub 0.01094f
C209 a_2632_0# sub 0.01094f
C210 a_2456_0# sub 0.01094f
C211 a_2280_0# sub 0.01094f
C212 a_2104_0# sub 0.01094f
C213 a_1928_0# sub 0.01094f
C214 a_1752_0# sub 0.01094f
C215 a_1576_0# sub 0.01094f
C216 a_1400_0# sub 0.01094f
C217 a_1224_0# sub 0.01094f
C218 a_1048_0# sub 0.01094f
C219 a_872_0# sub 0.01094f
C220 a_696_0# sub 0.01094f
C221 a_520_0# sub 0.01094f
C222 a_344_0# sub 0.01094f
C223 a_168_0# sub 0.01094f
C224 a_0_0# sub 0.09352f
C225 a_5524_n36# sub 0.04556f
C226 a_5348_n36# sub 0.0382f
C227 a_5172_n36# sub 0.0382f
C228 a_4996_n36# sub 0.0382f
C229 a_4820_n36# sub 0.0382f
C230 a_4644_n36# sub 0.0382f
C231 a_4468_n36# sub 0.0382f
C232 a_4292_n36# sub 0.0382f
C233 a_4116_n36# sub 0.0382f
C234 a_3940_n36# sub 0.0382f
C235 a_3764_n36# sub 0.0382f
C236 a_3588_n36# sub 0.0382f
C237 a_3412_n36# sub 0.0382f
C238 a_3236_n36# sub 0.0382f
C239 a_3060_n36# sub 0.0382f
C240 a_2884_n36# sub 0.0382f
C241 a_2708_n36# sub 0.0382f
C242 a_2532_n36# sub 0.0382f
C243 a_2356_n36# sub 0.0382f
C244 a_2180_n36# sub 0.0382f
C245 a_2004_n36# sub 0.0382f
C246 a_1828_n36# sub 0.0382f
C247 a_1652_n36# sub 0.0382f
C248 a_1476_n36# sub 0.0382f
C249 a_1300_n36# sub 0.0382f
C250 a_1124_n36# sub 0.0382f
C251 a_948_n36# sub 0.0382f
C252 a_772_n36# sub 0.0382f
C253 a_596_n36# sub 0.0382f
C254 a_420_n36# sub 0.0382f
C255 a_244_n36# sub 0.0382f
C256 a_68_n36# sub 0.04556f
.ends

.subckt pc_nmos_4 a_100_15# a_74_n21# sub a_0_0#
X0 a_100_15# a_74_n21# a_0_0# sub sg13_lv_nmos ad=0.1005p pd=1.34u as=0.1005p ps=1.34u w=0.15u l=0.13u
C0 a_0_0# a_100_15# 0.02238f
C1 a_100_15# sub 0.02279f
C2 a_74_n21# sub 0.04944f
C3 a_0_0# sub 0.02279f
.ends

.subckt pc_nmosHV_6 a_68_n36# a_668_0# sub a_744_n36# a_1344_0# a_0_0#
X0 a_668_0# a_68_n36# a_0_0# sub sg13_hv_nmos ad=0.57p pd=3.38u as=1.02p ps=6.68u w=3u l=3u
X1 a_1344_0# a_744_n36# a_668_0# sub sg13_hv_nmos ad=1.02p pd=6.68u as=0.57p ps=3.38u w=3u l=3u
C0 a_668_0# a_1344_0# 0.02872f
C1 a_744_n36# a_1344_0# 0.11296f
C2 a_0_0# a_668_0# 0.02872f
C3 a_68_n36# a_668_0# 0.11296f
C4 a_68_n36# a_744_n36# 0.01172f
C5 a_744_n36# a_668_0# 0.11296f
C6 a_68_n36# a_0_0# 0.11296f
C7 a_1344_0# sub 0.12772f
C8 a_668_0# sub 0.01267f
C9 a_0_0# sub 0.12772f
C10 a_744_n36# sub 1.17057f
C11 a_68_n36# sub 1.17057f
.ends

.subckt pc_pmosHV_3 a_268_0# a_896_n36# a_68_n36# a_344_n36# a_1648_0# a_1172_n36# a_1372_0#  a_620_n36# w_n124_n124# sub a_820_0# a_1448_n36# a_2200_0# a_1724_n36# a_1096_0#  a_544_0# a_0_0# a_2000_n36# a_1924_0#
X0 a_1096_0# a_896_n36# a_820_0# w_n124_n124# sg13_hv_pmos ad=0.19p pd=1.38u as=0.19p ps=1.38u w=1u l=1u
X1 a_1924_0# a_1724_n36# a_1648_0# w_n124_n124# sg13_hv_pmos ad=0.19p pd=1.38u as=0.19p ps=1.38u w=1u l=1u
X2 a_1648_0# a_1448_n36# a_1372_0# w_n124_n124# sg13_hv_pmos ad=0.19p pd=1.38u as=0.19p ps=1.38u w=1u l=1u
X3 a_268_0# a_68_n36# a_0_0# w_n124_n124# sg13_hv_pmos ad=0.19p pd=1.38u as=0.34p ps=2.68u w=1u l=1u
X4 a_1372_0# a_1172_n36# a_1096_0# w_n124_n124# sg13_hv_pmos ad=0.19p pd=1.38u as=0.19p ps=1.38u w=1u l=1u
X5 a_820_0# a_620_n36# a_544_0# w_n124_n124# sg13_hv_pmos ad=0.19p pd=1.38u as=0.19p ps=1.38u w=1u l=1u
X6 a_544_0# a_344_n36# a_268_0# w_n124_n124# sg13_hv_pmos ad=0.19p pd=1.38u as=0.19p ps=1.38u w=1u l=1u
X7 a_2200_0# a_2000_n36# a_1924_0# w_n124_n124# sg13_hv_pmos ad=0.34p pd=2.68u as=0.19p ps=1.38u w=1u l=1u
C0 a_620_n36# a_896_n36# 0.01172f
C1 w_n124_n124# a_268_0# 0.02041f
C2 w_n124_n124# a_2000_n36# 0.17263f
C3 a_0_0# w_n124_n124# 0.02256f
C4 a_344_n36# a_620_n36# 0.01172f
C5 a_896_n36# a_820_0# 0.02764f
C6 a_344_n36# a_544_0# 0.02764f
C7 a_1096_0# a_896_n36# 0.02764f
C8 w_n124_n124# a_1172_n36# 0.16807f
C9 a_2000_n36# a_1724_n36# 0.01172f
C10 a_1924_0# a_2000_n36# 0.02764f
C11 a_68_n36# a_344_n36# 0.01172f
C12 a_544_0# a_268_0# 0.02715f
C13 a_1648_0# w_n124_n124# 0.02041f
C14 w_n124_n124# a_1724_n36# 0.16807f
C15 a_1924_0# w_n124_n124# 0.02041f
C16 w_n124_n124# a_620_n36# 0.16807f
C17 a_68_n36# a_268_0# 0.02764f
C18 w_n124_n124# a_544_0# 0.02041f
C19 a_1448_n36# w_n124_n124# 0.16807f
C20 a_0_0# a_68_n36# 0.02764f
C21 w_n124_n124# a_1372_0# 0.02041f
C22 w_n124_n124# a_68_n36# 0.17263f
C23 a_1448_n36# a_1172_n36# 0.01172f
C24 a_1648_0# a_1724_n36# 0.02764f
C25 w_n124_n124# a_820_0# 0.02041f
C26 a_1648_0# a_1924_0# 0.02715f
C27 a_1924_0# a_1724_n36# 0.02764f
C28 a_1096_0# w_n124_n124# 0.02041f
C29 a_1172_n36# a_1372_0# 0.02764f
C30 a_1648_0# a_1448_n36# 0.02764f
C31 a_1448_n36# a_1724_n36# 0.01172f
C32 a_620_n36# a_544_0# 0.02764f
C33 a_1096_0# a_1172_n36# 0.02764f
C34 a_1648_0# a_1372_0# 0.02715f
C35 a_2000_n36# a_2200_0# 0.02764f
C36 a_620_n36# a_820_0# 0.02764f
C37 w_n124_n124# a_2200_0# 0.02256f
C38 a_1448_n36# a_1372_0# 0.02764f
C39 a_820_0# a_544_0# 0.02715f
C40 w_n124_n124# a_896_n36# 0.16807f
C41 a_344_n36# a_268_0# 0.02764f
C42 a_896_n36# a_1172_n36# 0.01172f
C43 a_1096_0# a_1372_0# 0.02715f
C44 a_1096_0# a_820_0# 0.02715f
C45 w_n124_n124# a_344_n36# 0.16807f
C46 a_1924_0# a_2200_0# 0.02715f
C47 a_0_0# a_268_0# 0.02715f
C48 a_2200_0# sub 0.03761f
C49 a_0_0# sub 0.03761f
C50 a_2000_n36# sub 0.05737f
C51 a_1724_n36# sub 0.05189f
C52 a_1448_n36# sub 0.05189f
C53 a_1172_n36# sub 0.05189f
C54 a_896_n36# sub 0.05189f
C55 a_620_n36# sub 0.05189f
C56 a_344_n36# sub 0.05189f
C57 a_68_n36# sub 0.05737f
.ends

.subckt pc_pmosHV a_68_n36# w_n124_n124# sub a_468_0# a_0_0#
X0 a_468_0# a_68_n36# a_0_0# w_n124_n124# sg13_hv_pmos ad=0.34p pd=2.68u as=0.34p ps=2.68u w=1u l=2u
C0 a_0_0# a_68_n36# 0.03479f
C1 w_n124_n124# a_468_0# 0.02609f
C2 a_0_0# a_468_0# 0.01425f
C3 a_468_0# a_68_n36# 0.03479f
C4 w_n124_n124# a_0_0# 0.02609f
C5 w_n124_n124# a_68_n36# 0.33329f
C6 a_468_0# sub 0.03761f
C7 a_0_0# sub 0.03761f
C8 a_68_n36# sub 0.11474f
.ends

.subckt pc_nmos_2 a_68_n36# sub a_1744_n36# a_3344_0# a_0_0# a_1668_0#
X0 a_3344_0# a_1744_n36# a_1668_0# sub sg13_lv_nmos ad=0.17p pd=1.68u as=95f ps=0.88u w=0.5u l=8u
X1 a_1668_0# a_68_n36# a_0_0# sub sg13_lv_nmos ad=95f pd=0.88u as=0.17p ps=1.68u w=0.5u l=8u
C0 a_68_n36# a_1668_0# 0.02075f
C1 a_1668_0# a_1744_n36# 0.02075f
C2 a_68_n36# a_0_0# 0.02075f
C3 a_3344_0# a_1744_n36# 0.02075f
C4 a_68_n36# a_1744_n36# 0.01172f
C5 a_3344_0# sub 0.03407f
C6 a_1668_0# sub 0.01712f
C7 a_0_0# sub 0.03407f
C8 a_1744_n36# sub 1.33615f
C9 a_68_n36# sub 1.33615f
.ends

.subckt pc_nmosHV_4 a_944_n36# a_68_n36# sub a_0_0# a_1744_0# a_868_0#
X0 a_1744_0# a_944_n36# a_868_0# sub sg13_hv_nmos ad=1.36p pd=8.68u as=0.76p ps=4.38u w=4u l=4u
X1 a_868_0# a_68_n36# a_0_0# sub sg13_hv_nmos ad=0.76p pd=4.38u as=1.36p ps=8.68u w=4u l=4u
C0 a_1744_0# a_868_0# 0.02877f
C1 a_68_n36# a_868_0# 0.15667f
C2 a_0_0# a_868_0# 0.02877f
C3 a_868_0# a_944_n36# 0.15667f
C4 a_68_n36# a_0_0# 0.15667f
C5 a_1744_0# a_944_n36# 0.15667f
C6 a_68_n36# a_944_n36# 0.01172f
C7 a_1744_0# sub 0.16607f
C8 a_868_0# sub 0.01267f
C9 a_0_0# sub 0.16607f
C10 a_944_n36# sub 1.90315f
C11 a_68_n36# sub 1.90315f
.ends

.subckt pc_pmosHV_1 a_944_0# a_68_n36# w_n124_n124# sub a_468_0# a_0_0# a_544_n36#
X0 a_944_0# a_544_n36# a_468_0# w_n124_n124# sg13_hv_pmos ad=0.34p pd=2.68u as=0.19p ps=1.38u w=1u l=2u
X1 a_468_0# a_68_n36# a_0_0# w_n124_n124# sg13_hv_pmos ad=0.19p pd=1.38u as=0.34p ps=2.68u w=1u l=2u
C0 a_944_0# a_544_n36# 0.03479f
C1 a_544_n36# a_68_n36# 0.01172f
C2 a_468_0# a_0_0# 0.01425f
C3 w_n124_n124# a_0_0# 0.02609f
C4 w_n124_n124# a_468_0# 0.02748f
C5 a_0_0# a_68_n36# 0.03479f
C6 a_944_0# a_468_0# 0.01425f
C7 a_544_n36# a_468_0# 0.03479f
C8 a_944_0# w_n124_n124# 0.02609f
C9 w_n124_n124# a_544_n36# 0.32873f
C10 a_468_0# a_68_n36# 0.03479f
C11 w_n124_n124# a_68_n36# 0.32873f
C12 a_944_0# sub 0.03761f
C13 a_0_0# sub 0.03761f
C14 a_544_n36# sub 0.10926f
C15 a_68_n36# sub 0.10926f
.ends

.subckt RAMP_V2 VDD GND IBIAS minus plus Vout
Xpmos_8_0 m2_3160_12842# V1_CM V1_CM m2_2104_7148# VDD m2_2104_7148# GND m2_3160_12842#  x1.vcmfb a_8611_8716# x1.vcmfb pc_pmos_8
XnmosHV_2_0 nlo nlo m2_8707_2888# nlo GND GND GND nlo GND m2_14638_2504# nlo nlo nlo  nlo m2_15114_2504# GND GND nlo GND nlo nlo nlo pc_nmosHV_2
Xnmos_10_0 m2_10720_9278# mp_dz mp_dz Vo_STG1 Vo_STG1 m2_10720_9278# GND mp_dz m2_10720_9278#  Vo_STG1 m2_10720_9278# Vo_STG1 Vo_STG1 Vo_STG1 pc_nmos_10
Xcmim_0 GND xr.o1 xr.z pc_cmim
Xrhigh_60 m2_2871_6956# GND m2_2711_4634# rhigh_60/a_0_0# pc_rhigh
Xpmos_6_0 VDD m3_7171_1046# VDD VDD GND VDD m3_7171_1046# pc_pmos_6
Xrhigh_61 m2_2551_6956# GND m2_2711_4634# rhigh_61/a_0_0# pc_rhigh
Xrhigh_50 m2_4471_6956# GND m2_4311_4730# rhigh_50/a_0_0# pc_rhigh
Xnmos_9_0 mn_dz GND GND Vo_STG1 GND GND mn_dz Vo_STG1 GND Vo_STG1 pc_nmos_9
Xrhigh_62 m2_2551_6956# GND m2_2391_4634# rhigh_62/a_0_0# pc_rhigh
Xrhigh_51 m2_4151_6956# GND m2_4311_4730# rhigh_51/a_0_0# pc_rhigh
Xrhigh_40 V1_CM GND m2_5911_4826# rhigh_40/a_0_0# pc_rhigh
Xrhigh_63 m2_2231_6956# GND m2_2391_4634# rhigh_63/a_0_0# pc_rhigh
Xrhigh_52 m2_4151_6956# GND m2_3991_4730# rhigh_52/a_0_0# pc_rhigh
Xrhigh_41 m2_5751_6956# GND m2_5911_4826# rhigh_41/a_0_0# pc_rhigh
Xrhigh_30 m2_11163_5114# GND m2_11323_2792# rhigh_30/a_0_0# pc_rhigh
Xpmos_4_0 VDD VDD VDD GND VDD pc_pmos_4
Xrhigh_42 m2_5751_6956# GND m2_5591_4826# rhigh_42/a_0_0# pc_rhigh
Xrhigh_31 m2_11163_5114# GND m2_11003_2408# rhigh_31/a_0_0# pc_rhigh
Xrhigh_20 m2_12763_4826# GND m2_12923_2408# rhigh_20/a_0_0# pc_rhigh
Xrhigh_64 m2_2231_6956# GND m2_2071_4634# rhigh_64/a_0_0# pc_rhigh
Xrhigh_53 m2_3831_6956# GND m2_3991_4730# rhigh_53/a_0_0# pc_rhigh
Xcmim_1_0 GND xs.o1 xs.z pc_cmim_1
Xnmos_7_0 GND x1.vcmfb GND a_8611_8716# GND a_8611_8716# x1.vcmfb GND pc_nmos_7
Xrhigh_54 m2_3831_6956# GND m2_3671_4634# rhigh_54/a_0_0# pc_rhigh
Xrhigh_65 m2_1911_6956# GND m2_2071_4634# rhigh_65/a_0_0# pc_rhigh
Xrhigh_43 m2_5431_6956# GND m2_5591_4826# rhigh_43/a_0_0# pc_rhigh
Xrhigh_32 m2_10843_5114# GND m2_11003_2408# rhigh_32/a_0_0# pc_rhigh
Xrhigh_21 m2_12763_4826# GND m2_12603_2792# rhigh_21/a_0_0# pc_rhigh
Xrhigh_10 m2_14363_4826# GND m2_14523_2696# rhigh_10/a_0_0# pc_rhigh
Xrhigh_55 m2_3511_6956# GND m2_3671_4634# rhigh_55/a_0_0# pc_rhigh
Xrhigh_66 m2_1911_6956# GND m2_1751_4634# rhigh_66/a_0_0# pc_rhigh
Xrhigh_44 m2_5431_6956# GND m2_5271_4826# rhigh_44/a_0_0# pc_rhigh
Xrhigh_33 m2_10843_5114# GND mp_dz rhigh_33/a_0_0# pc_rhigh
Xrhigh_22 m2_12443_4826# GND m2_12603_2792# rhigh_22/a_0_0# pc_rhigh
Xrhigh_11 m2_14363_4826# GND m2_14203_2696# rhigh_11/a_0_0# pc_rhigh
Xrhigh_34 Vo_STG1 GND m2_2104_7148# rhigh_34/a_0_0# pc_rhigh
Xrhigh_56 m2_3511_6956# GND m2_3351_4634# rhigh_56/a_0_0# pc_rhigh
Xrhigh_67 m2_1591_6956# GND m2_1751_4634# rhigh_67/a_0_0# pc_rhigh
Xrhigh_45 m2_5111_6956# GND m2_5271_4826# rhigh_45/a_0_0# pc_rhigh
Xrhigh_23 m2_12443_4826# GND m2_12283_2792# rhigh_23/a_0_0# pc_rhigh
Xrhigh_12 m2_14043_4826# GND m2_14203_2696# rhigh_12/a_0_0# pc_rhigh
Xpmos_2_0 VDD VDD VDD GND VDD pc_pmos_2
Xnmos_5_0 GND GND GND GND pc_nmos_5
XnmosHV_7_0 GND mn_dz GND mn_dz GND mn_dz GND mn_dz GND GND GND Vout Vout GND pc_nmosHV_7
Xrhigh_35 Vo1n GND m2_2104_7148# rhigh_35/a_0_0# pc_rhigh
Xrhigh_57 m2_3191_6956# GND m2_3351_4634# rhigh_57/a_0_0# pc_rhigh
Xrhigh_68 m2_1591_6956# GND m2_1431_4634# rhigh_68/a_0_0# pc_rhigh
Xrhigh_46 m2_5111_6956# GND m2_4951_4826# rhigh_46/a_0_0# pc_rhigh
Xrhigh_24 m2_12123_4826# GND m2_12283_2792# rhigh_24/a_0_0# pc_rhigh
Xrhigh_13 m2_14043_4826# GND m2_13883_2408# rhigh_13/a_0_0# pc_rhigh
Xpmos_2_1 VDD VDD VDD GND VDD pc_pmos_2
Xnmos_5_1 GND GND GND GND pc_nmos_5
Xrhigh_58 m2_3191_6956# GND m2_3031_4634# rhigh_58/a_0_0# pc_rhigh
Xrhigh_47 m2_4791_6956# GND m2_4951_4826# rhigh_47/a_0_0# pc_rhigh
Xrhigh_36 V1_CM GND m2_6551_4826# rhigh_36/a_0_0# pc_rhigh
Xrhigh_25 m2_12123_4826# GND m2_11963_2408# rhigh_25/a_0_0# pc_rhigh
Xrhigh_14 m2_13723_4826# GND m2_13883_2408# rhigh_14/a_0_0# pc_rhigh
XpmosHV_4_0 VDD VDD VDD Vout VDD mp_dz mp_dz VDD Vout GND VDD irn mp_dz mp_dz VDD  VDD VDD irn irn pc_pmosHV_4
Xrhigh_69 xs.VSV GND m2_1431_4634# rhigh_69/a_0_0# pc_rhigh
Xpmos_2_2 VDD VDD VDD GND VDD pc_pmos_2
Xrhigh_59 m2_2871_6956# GND m2_3031_4634# rhigh_59/a_0_0# pc_rhigh
Xrhigh_48 m2_4791_6956# GND m2_4631_4730# rhigh_48/a_0_0# pc_rhigh
Xrhigh_37 m2_6391_7436# GND m2_6551_4826# rhigh_37/a_0_0# pc_rhigh
Xrhigh_26 m2_11803_4826# GND m2_11963_2408# rhigh_26/a_0_0# pc_rhigh
Xrhigh_15 m2_13723_4826# GND m2_13563_2792# rhigh_15/a_0_0# pc_rhigh
Xpmos_2_3 VDD VDD VDD GND VDD pc_pmos_2
Xnmos_3_0 GND vtrip GND GND vtrip GND pc_nmos_3
Xrhigh_49 m2_4471_6956# GND m2_4631_4730# rhigh_49/a_0_0# pc_rhigh
Xrhigh_38 m2_6391_7436# GND m2_6231_4826# rhigh_38/a_0_0# pc_rhigh
XnmosHV_5_0 GND GND GND GND pc_nmosHV_5
Xrhigh_27 m2_11803_4826# GND m2_11643_2792# rhigh_27/a_0_0# pc_rhigh
Xrhigh_16 m2_13403_4826# GND m2_13563_2792# rhigh_16/a_0_0# pc_rhigh
XnmosHV_5_1 GND GND GND GND pc_nmosHV_5
Xrhigh_39 vtrip GND m2_6231_4826# rhigh_39/a_0_0# pc_rhigh
Xrhigh_28 m2_11483_5114# GND m2_11643_2792# rhigh_28/a_0_0# pc_rhigh
Xrhigh_17 m2_13403_4826# GND m2_13243_2792# rhigh_17/a_0_0# pc_rhigh
XpmosHV_2_0 VDD VDD VDD GND VDD pc_pmosHV_2
Xnmos_0 GND IBIAS GND IBIAS GND IBIAS irn IBIAS GND GND pc_nmos
Xrhigh_29 m2_11483_5114# GND m2_11323_2792# rhigh_29/a_0_0# pc_rhigh
Xrhigh_18 m2_13083_4826# GND m2_13243_2792# rhigh_18/a_0_0# pc_rhigh
Xnmos_1 GND IBIAS GND VCTRLP GND IBIAS VCTRLP IBIAS GND GND pc_nmos
XpmosHV_2_1 VDD VDD VDD GND VDD pc_pmosHV_2
Xnmos_1_0 IBIAS IBIAS GND xs.VSV GND GND VCTRLN GND pc_nmos_1
Xpmos_9_0 m2_15030_12842# VDD VCTRLP VCTRLP vtrip vtrip VDD VCTRLP VCTRLP m2_15030_12842#  GND m2_15030_12842# VDD m2_15030_12842# vtrip vtrip VCTRLP vtrip VCTRLP VDD VCTRLP  pc_pmos_9
Xrhigh_19 m2_13083_4826# GND m2_12923_2408# rhigh_19/a_0_0# pc_rhigh
XnmosHV_3_0 GND GND GND GND pc_nmosHV_3
Xnmos_1_1 IBIAS GND GND GND IBIAS GND GND m3_7171_1046# pc_nmos_1
XnmosHV_3_1 GND GND GND GND pc_nmosHV_3
XnmosHV_0 GND GND GND GND pc_nmosHV
Xpmos_7_0 VDD VDD VDD GND VDD pc_pmos_7
XnmosHV_1_0 m2_3894_2504# nlo GND m2_4846_2504# nlo nlo nlo m2_5322_2504# GND nlo  GND GND GND nlo nlo nlo nlo nlo nlo nlo GND nlo nlo m2_3418_2408# m2_4370_2504#  nlo m2_2987_2696# nlo nlo GND nlo GND pc_nmosHV_1
XnmosHV_1 GND GND GND GND pc_nmosHV
Xpmos_7_1 VDD VDD VDD GND VDD pc_pmos_7
Xpmos_5_0 m3_7171_1046# m3_7171_1046# VDD m3_7171_1046# m3_7171_1046# m3_7171_1046#  m3_7171_1046# m2_3160_12842# m3_7171_1046# m3_7171_1046# VDD it1 VDD it1 m3_7171_1046#  VDD VDD m3_7171_1046# m3_7171_1046# GND VDD m3_7171_1046# m3_7171_1046# m3_7171_1046#  VDD it1 m2_3160_12842# m3_7171_1046# it1 VDD it1 m3_7171_1046# m3_7171_1046# m3_7171_1046#  VDD it1 it1 m3_7171_1046# m3_7171_1046# m3_7171_1046# it1 m3_7171_1046# m2_3160_12842#  m3_7171_1046# m3_7171_1046# VDD m3_7171_1046# VDD VDD it1 it1 VDD VDD pc_pmos_5
Xnmos_8_0 VCTRLN GND m2_10720_9278# GND GND VCTRLN VCTRLN GND VCTRLN VCTRLN m2_10720_9278#  GND GND m2_10720_9278# GND VCTRLN GND GND pc_nmos_8
Xrhigh_0 m2_15963_4634# GND xs.z rhigh_0/a_0_0# pc_rhigh
Xpmos_3_0 Vo_STG1 m2_10786_9662# VCTRLP m2_10786_9662# m2_10786_9662# Vo_STG1 VDD  VDD VCTRLP Vo_STG1 VCTRLP VCTRLP mn_dz Vo_STG1 VDD Vo_STG1 mn_dz VCTRLP VDD VCTRLP  m2_10786_9662# VDD VCTRLP Vo_STG1 m2_10786_9662# m2_10786_9662# m2_10786_9662# GND  m2_10786_9662# mn_dz VDD mn_dz m2_10786_9662# m2_10786_9662# mn_dz m2_10786_9662#  Vo_STG1 Vo_STG1 VDD Vo_STG1 VCTRLP VCTRLP mp_dz Vo_STG1 VCTRLP VDD VCTRLP VCTRLP  VCTRLP VCTRLP m2_10786_9662# VDD VCTRLP pc_pmos_3
Xrhigh_1 m2_15963_4634# GND xs.VSV rhigh_1/a_0_0# pc_rhigh
Xnmos_6_0 Vo_STG1 x1.vcmfb Vo1n x1.vcmfb GND GND x1.vcmfb GND Vo1n x1.vcmfb x1.vcmfb  x1.vcmfb GND GND Vo1n x1.vcmfb x1.vcmfb Vo_STG1 pc_nmos_6
Xrhigh_2 m2_15643_4634# GND xr.z rhigh_2/a_0_0# pc_rhigh
Xrhigh_3 m2_15643_4634# GND VCTRLN rhigh_3/a_0_0# pc_rhigh
Xpmos_0 VDD VDD GND VDD VDD pc_pmos
Xpmos_1_0 it1 it1 minus minus minus it1 it1 minus minus minus Vo_STG1 Vo1n Vo_STG1  Vo1n minus Vo1n Vo_STG1 it1 VDD plus plus it1 plus plus plus plus plus plus Vo1n  Vo_STG1 GND it1 it1 it1 it1 plus plus plus minus Vo_STG1 Vo_STG1 plus plus plus  Vo1n plus plus it1 it1 it1 it1 it1 it1 Vo1n Vo1n Vo1n minus Vo_STG1 Vo_STG1 minus  minus minus Vo1n minus minus minus minus pc_pmos_1
Xrhigh_4 m2_15323_4634# GND xr.vgps rhigh_4/a_0_0# pc_rhigh
Xpmos_1 VDD VDD GND VDD VDD pc_pmos
Xnmos_4_0 GND GND GND GND pc_nmos_4
XnmosHV_6_0 Vo1n m2_8707_2888# GND Vo_STG1 xs.o1 a_9726_6394# pc_nmosHV_6
Xrhigh_5 m2_15323_4634# GND m2_15163_2696# rhigh_5/a_0_0# pc_rhigh
Xnmos_4_1 GND GND GND GND pc_nmos_4
XpmosHV_3_0 VDD m3_14806_950# xs.o1 m3_14806_950# m3_14806_950# m3_14806_950# VDD  m3_14806_950# VDD GND VDD m3_14806_950# m3_14806_950# m3_14806_950# m3_14806_950#  m3_14806_950# xs.VSV m3_14806_950# VDD pc_pmosHV_3
Xrhigh_6 m2_15003_4826# GND m2_15163_2696# rhigh_6/a_0_0# pc_rhigh
XpmosHV_3_1 VDD m3_14806_950# xr.o1 m3_14806_950# m3_14806_950# m3_14806_950# VDD  m3_14806_950# VDD GND VDD m3_14806_950# nlo m3_14806_950# m3_14806_950# m3_14806_950#  VCTRLN m3_14806_950# VDD pc_pmosHV_3
Xrhigh_7 m2_15003_4826# GND m2_14843_2504# rhigh_7/a_0_0# pc_rhigh
XpmosHV_0 VDD VDD GND VDD VDD pc_pmosHV
Xnmos_2_0 IBIAS GND GND GND m3_14806_950# GND pc_nmos_2
XnmosHV_4_0 xr.vgps irn GND a_8594_6394# xr.o1 m2_2987_2696# pc_nmosHV_4
Xrhigh_8 m2_14683_4826# GND m2_14843_2504# rhigh_8/a_0_0# pc_rhigh
XpmosHV_1 VDD VDD GND VDD VDD pc_pmosHV
Xrhigh_9 m2_14683_4826# GND m2_14523_2696# rhigh_9/a_0_0# pc_rhigh
XpmosHV_1_0 xs.o1 a_9726_6394# VDD GND VDD a_9726_6394# a_9726_6394# pc_pmosHV_1
XpmosHV_1_1 xr.o1 a_8594_6394# VDD GND VDD a_8594_6394# a_8594_6394# pc_pmosHV_1
C0 irn m2_3991_4730# 0.13261f
C1 m2_11803_4826# xr.o1 0.18582f
C2 m2_3160_12842# it1 4.79843f
C3 plus vtrip 0.01737f
C4 m2_14843_2504# xs.VSV 0.18207f
C5 m2_2231_6956# m2_2104_7148# 0.01057f
C6 xr.z a_8594_6394# 1.53483f
C7 m2_12923_2408# nlo 0.30117f
C8 rhigh_44/a_0_0# rhigh_45/a_0_0# 0.23988f
C9 xs.o1 VCTRLN 0.35605f
C10 Vo_STG1 xs.z 0.43343f
C11 a_8611_8716# m2_2104_7148# 0.01477f
C12 m2_6231_4826# VDD 0.06404f
C13 xr.z m2_2711_4634# 0.05597f
C14 xs.o1 V1_CM 0.16338f
C15 m2_12123_4826# m2_12443_4826# 0.19121f
C16 m2_4631_4730# xr.vgps 0.04225f
C17 rhigh_4/a_0_0# vtrip 0.01612f
C18 mp_dz m2_12603_2792# 0.18468f
C19 m2_3894_2504# nlo 0.01462f
C20 rhigh_44/a_0_0# VDD 0.02056f
C21 m2_4631_4730# m2_4311_4730# 0.27039f
C22 m2_14843_2504# nlo 0.0171f
C23 Vo1n xr.z 1.48495f
C24 VCTRLP VCTRLN 0.45705f
C25 m2_12123_4826# irn 0.03124f
C26 xs.VSV m2_4471_6956# 0.20999f
C27 VCTRLN IBIAS 0.1721f
C28 m2_11163_5114# xs.o1 0.20997f
C29 VCTRLP V1_CM 1.16399f
C30 rhigh_25/a_0_0# rhigh_26/a_0_0# 0.23988f
C31 rhigh_10/a_0_0# xs.VSV 0.01818f
C32 minus V1_CM 0.01538f
C33 xr.z rhigh_62/a_0_0# 0.02452f
C34 vtrip VCTRLN 1.2232f
C35 rhigh_25/a_0_0# xr.z 0.01138f
C36 m2_14203_2696# VCTRLN 0.04544f
C37 mn_dz m2_2104_7148# 0.41181f
C38 rhigh_43/a_0_0# VDD 0.02062f
C39 xs.VSV m2_15114_2504# 0.14002f
C40 vtrip V1_CM 0.17946f
C41 rhigh_63/a_0_0# rhigh_62/a_0_0# 0.23988f
C42 m3_7171_1046# xr.o1 0.31525f
C43 mp_dz VDD 1.73221f
C44 rhigh_46/a_0_0# rhigh_45/a_0_0# 0.23988f
C45 xr.z m2_11323_2792# 0.01959f
C46 m2_11643_2792# VCTRLN 0.05011f
C47 m2_14203_2696# m2_13883_2408# 0.19147f
C48 m2_5111_6956# m2_5431_6956# 0.158f
C49 Vo_STG1 xr.o1 2.25535f
C50 xr.o1 xs.z 0.03584f
C51 it1 x1.vcmfb 2.4344f
C52 VDD rhigh_61/a_0_0# 0.02056f
C53 nlo m2_15114_2504# 0.01462f
C54 irn m2_12443_4826# 0.03124f
C55 m2_3991_4730# VDD 0.08903f
C56 m2_15003_4826# m2_14683_4826# 0.19121f
C57 rhigh_46/a_0_0# VDD 0.02056f
C58 it1 VDD 6.77594f
C59 m2_14523_2696# m2_14843_2504# 0.19147f
C60 Vo_STG1 a_9726_6394# 0.04437f
C61 rhigh_23/a_0_0# xr.z 0.01011f
C62 mp_dz xs.VSV 0.18068f
C63 irn m2_2987_2696# 0.05839f
C64 m3_14806_950# m2_8707_2888# 0.01985f
C65 m2_4791_6956# xr.z 0.02758f
C66 irn m2_15163_2696# 0.02079f
C67 VDD m2_2551_6956# 0.04823f
C68 rhigh_22/a_0_0# rhigh_23/a_0_0# 0.23988f
C69 m2_10843_5114# xs.o1 0.21857f
C70 xr.z m2_1431_4634# 0.06943f
C71 m2_4370_2504# m2_4846_2504# 0.01927f
C72 m2_8707_2888# a_8594_6394# 0.01028f
C73 rhigh_8/a_0_0# m3_14806_950# 0.02476f
C74 m2_10786_9662# mn_dz 0.72129f
C75 m2_3418_2408# xr.z 0.01933f
C76 m2_15323_4634# m2_15003_4826# 0.11431f
C77 m2_5591_4826# VDD 0.09347f
C78 mp_dz nlo 0.03575f
C79 rhigh_52/a_0_0# VDD 0.02056f
C80 m2_4951_4826# xr.vgps 0.21217f
C81 rhigh_49/a_0_0# rhigh_50/a_0_0# 0.23988f
C82 xs.VSV m2_2551_6956# 0.20999f
C83 rhigh_24/a_0_0# VCTRLN 0.014f
C84 mp_dz m2_11003_2408# 0.23154f
C85 Vout xs.o1 0.01397f
C86 VCTRLP a_8611_8716# 0.0253f
C87 m2_3160_12842# x1.vcmfb 1.02394f
C88 Vo1n m2_6551_4826# 0.22682f
C89 xs.o1 xr.vgps 0.03522f
C90 plus a_8594_6394# 0.0218f
C91 minus a_8611_8716# 0.0406f
C92 m2_15003_4826# m3_14806_950# 0.18949f
C93 a_9726_6394# xr.o1 2.61932f
C94 rhigh_11/a_0_0# xs.VSV 0.01558f
C95 rhigh_39/a_0_0# xr.z 0.02404f
C96 vtrip a_8611_8716# 0.27143f
C97 m2_3160_12842# VDD 9.7908f
C98 xr.z m3_7171_1046# 3.20629f
C99 mn_dz xs.o1 0.012f
C100 VCTRLP Vout 0.07578f
C101 irn VDD 0.82255f
C102 VCTRLP xr.vgps 0.02427f
C103 Vo_STG1 xr.z 1.14885f
C104 xr.z xs.z 0.26758f
C105 m2_5431_6956# xr.z 0.0289f
C106 rhigh_21/a_0_0# rhigh_20/a_0_0# 0.23988f
C107 rhigh_59/a_0_0# xr.z 0.02452f
C108 Vo1n plus 0.0415f
C109 minus xr.vgps 0.03603f
C110 m2_8707_2888# m2_11323_2792# 0.21045f
C111 m3_14806_950# VCTRLN 0.03286f
C112 rhigh_36/a_0_0# VDD 0.05729f
C113 m2_10720_9278# VCTRLN 0.01312f
C114 vtrip Vout 2.26992f
C115 rhigh_65/a_0_0# rhigh_66/a_0_0# 0.23988f
C116 m2_5271_4826# m2_5591_4826# 0.23974f
C117 VCTRLP mn_dz 0.03153f
C118 vtrip xr.vgps 1.25431f
C119 m3_14806_950# V1_CM 0.01658f
C120 m2_10720_9278# V1_CM 0.02238f
C121 m2_11963_2408# nlo 0.30649f
C122 irn m2_11483_5114# 0.03124f
C123 m2_5751_6956# V1_CM 0.158f
C124 rhigh_19/a_0_0# VCTRLP 0.01129f
C125 irn xs.VSV 0.04817f
C126 m2_12763_4826# m2_12443_4826# 0.19121f
C127 a_8594_6394# V1_CM 0.04699f
C128 vtrip mn_dz 2.35745f
C129 mp_dz m2_12283_2792# 0.18192f
C130 m2_4846_2504# a_8594_6394# 0.14002f
C131 rhigh_29/a_0_0# xr.z 0.01377f
C132 m2_14043_4826# xr.vgps 0.21031f
C133 rhigh_50/a_0_0# rhigh_51/a_0_0# 0.23988f
C134 rhigh_9/a_0_0# m3_14806_950# 0.01472f
C135 irn m2_12763_4826# 0.03124f
C136 mp_dz m2_2104_7148# 0.08678f
C137 Vo1n V1_CM 0.02132f
C138 irn nlo 0.08855f
C139 rhigh_45/a_0_0# VDD 0.02056f
C140 x1.vcmfb VDD 0.57091f
C141 m2_2987_2696# nlo 0.0116f
C142 m2_5111_6956# xr.z 0.02757f
C143 rhigh_25/a_0_0# VCTRLN 0.01505f
C144 xr.z xr.o1 2.32609f
C145 VCTRLP m2_12923_2408# 0.01207f
C146 rhigh_3/a_0_0# vtrip 0.01893f
C147 rhigh_18/a_0_0# rhigh_17/a_0_0# 0.23988f
C148 m2_12923_2408# IBIAS 0.01719f
C149 m2_2391_4634# VDD 0.08627f
C150 rhigh_21/a_0_0# rhigh_22/a_0_0# 0.23988f
C151 rhigh_66/a_0_0# xr.z 0.02452f
C152 m2_15030_12842# VCTRLP 0.02436f
C153 irn rhigh_6/a_0_0# 0.01871f
C154 m2_14683_4826# xr.vgps 0.21031f
C155 xr.z a_9726_6394# 0.94064f
C156 m2_11323_2792# VCTRLN 0.05604f
C157 m2_12603_2792# nlo 0.01131f
C158 rhigh_2/a_0_0# rhigh_3/a_0_0# 0.23988f
C159 m2_15030_12842# vtrip 0.8182f
C160 irn rhigh_7/a_0_0# 0.02131f
C161 m2_11483_5114# VDD 0.2249f
C162 rhigh_65/a_0_0# xr.z 0.02452f
C163 m2_12283_2792# m2_11963_2408# 0.16082f
C164 xr.z m2_3671_4634# 0.05745f
C165 xs.VSV VDD 12.72612f
C166 m2_10786_9662# mp_dz 0.01068f
C167 Vo_STG1 m2_8707_2888# 0.06158f
C168 m2_4151_6956# xr.z 0.02761f
C169 rhigh_23/a_0_0# VCTRLN 0.01321f
C170 m2_15323_4634# xr.vgps 0.16452f
C171 rhigh_41/a_0_0# rhigh_42/a_0_0# 0.23988f
C172 nlo VDD 0.18518f
C173 m2_13403_4826# m3_14806_950# 0.18974f
C174 irn m2_4631_4730# 0.1818f
C175 m2_1911_6956# VDD 0.04872f
C176 minus m2_6231_4826# 0.03328f
C177 rhigh_68/a_0_0# xr.z 0.02452f
C178 rhigh_38/a_0_0# VDD 0.02217f
C179 m2_5271_4826# VDD 0.09347f
C180 plus m3_7171_1046# 0.5771f
C181 m2_3160_12842# m2_2104_7148# 0.01257f
C182 Vo_STG1 plus 0.10267f
C183 rhigh_17/a_0_0# mp_dz 0.01697f
C184 m3_14806_950# xr.vgps 0.33772f
C185 m2_3894_2504# m2_4370_2504# 0.01927f
C186 Vo1n rhigh_42/a_0_0# 0.01364f
C187 rhigh_26/a_0_0# xr.z 0.01208f
C188 mp_dz xs.o1 0.05393f
C189 Vo1n a_8611_8716# 0.05299f
C190 m2_3031_4634# m2_2711_4634# 0.30104f
C191 rhigh_16/a_0_0# mp_dz 0.0286f
C192 rhigh_0/a_0_0# vtrip 0.01063f
C193 a_8594_6394# xr.vgps 0.09423f
C194 nlo xs.VSV 0.29169f
C195 mn_dz m3_14806_950# 0.02124f
C196 m2_1911_6956# xs.VSV 0.20999f
C197 m2_10720_9278# mn_dz 0.68527f
C198 m2_8707_2888# xr.o1 0.03792f
C199 m2_12283_2792# m2_12603_2792# 0.17588f
C200 m3_7171_1046# VCTRLN 0.49682f
C201 rhigh_63/a_0_0# xr.z 0.02452f
C202 VCTRLP mp_dz 0.7829f
C203 rhigh_53/a_0_0# xr.z 0.02452f
C204 Vo1n xr.vgps 0.54062f
C205 xs.z VCTRLN 0.0115f
C206 Vo_STG1 VCTRLN 0.35178f
C207 rhigh_66/a_0_0# rhigh_67/a_0_0# 0.23988f
C208 m3_7171_1046# V1_CM 0.02635f
C209 m2_8707_2888# a_9726_6394# 0.67318f
C210 m2_1591_6956# VDD 0.04974f
C211 Vo_STG1 V1_CM 0.33603f
C212 xs.z V1_CM 0.13506f
C213 m2_13083_4826# m2_13403_4826# 0.19121f
C214 vtrip mp_dz 0.07643f
C215 m2_12123_4826# xs.o1 0.04325f
C216 rhigh_15/a_0_0# rhigh_16/a_0_0# 0.23988f
C217 rhigh_55/a_0_0# VDD 0.02056f
C218 m2_11003_2408# nlo 0.20982f
C219 x1.vcmfb m2_2104_7148# 0.67915f
C220 m2_4631_4730# VDD 0.08903f
C221 plus xr.o1 0.03321f
C222 minus it1 1.17255f
C223 VDD rhigh_40/a_0_0# 0.02153f
C224 m2_13083_4826# xr.vgps 0.21031f
C225 rhigh_61/a_0_0# rhigh_60/a_0_0# 0.23988f
C226 m2_11163_5114# Vo_STG1 0.03813f
C227 mp_dz m2_11643_2792# 0.18192f
C228 m2_2104_7148# VDD 0.69857f
C229 rhigh_29/a_0_0# VCTRLN 0.02316f
C230 m2_14523_2696# xs.VSV 0.03597f
C231 m2_1591_6956# xs.VSV 0.32032f
C232 rhigh_47/a_0_0# xr.z 0.02452f
C233 rhigh_54/a_0_0# VDD 0.02056f
C234 m3_14806_950# m2_14843_2504# 0.03183f
C235 m2_3351_4634# m2_3671_4634# 0.30104f
C236 Vo1n m2_5911_4826# 0.02352f
C237 rhigh_69/a_0_0# VDD 0.02753f
C238 m2_3894_2504# a_8594_6394# 0.1547f
C239 rhigh_68/a_0_0# rhigh_67/a_0_0# 0.23988f
C240 xr.o1 VCTRLN 0.1307f
C241 VCTRLP m2_11963_2408# 0.01033f
C242 m2_1591_6956# m2_1911_6956# 0.158f
C243 m2_2071_4634# m2_2391_4634# 0.30104f
C244 m2_11963_2408# IBIAS 0.01691f
C245 m2_2071_4634# VDD 0.08629f
C246 m2_11803_4826# xr.vgps 0.21031f
C247 xr.o1 V1_CM 0.07544f
C248 rhigh_30/a_0_0# rhigh_29/a_0_0# 0.23988f
C249 rhigh_6/a_0_0# rhigh_7/a_0_0# 0.23988f
C250 irn xs.o1 0.03218f
C251 rhigh_57/a_0_0# VDD 0.02056f
C252 m2_12443_4826# VCTRLP 0.02933f
C253 xr.z m2_8707_2888# 0.3933f
C254 rhigh_36/a_0_0# rhigh_37/a_0_0# 0.23988f
C255 m2_5322_2504# nlo 0.016f
C256 m2_3160_12842# VCTRLP 0.47624f
C257 rhigh_67/a_0_0# xr.z 0.02452f
C258 m2_2104_7148# nlo 0.03774f
C259 m2_6551_4826# xr.z 0.04635f
C260 a_9726_6394# V1_CM 0.03725f
C261 m2_11163_5114# xr.o1 0.03518f
C262 m2_6391_7436# xr.z 0.04721f
C263 irn VCTRLP 5.58699f
C264 m2_10786_9662# VDD 4.15633f
C265 irn minus 0.03673f
C266 irn IBIAS 0.152f
C267 m2_10843_5114# Vo_STG1 0.03493f
C268 m2_11643_2792# m2_11963_2408# 0.16082f
C269 xr.z m2_3351_4634# 0.05609f
C270 m3_7171_1046# a_8611_8716# 1.43702f
C271 Vo_STG1 a_8611_8716# 0.07615f
C272 irn vtrip 0.56726f
C273 plus xr.z 1.49837f
C274 Vo1n m2_6231_4826# 0.23736f
C275 VCTRLP m2_12603_2792# 0.0222f
C276 rhigh_64/a_0_0# VDD 0.02056f
C277 m3_7171_1046# xr.vgps 0.02549f
C278 Vout xs.z 0.46821f
C279 m2_14043_4826# irn 0.03124f
C280 m2_4951_4826# VDD 0.09347f
C281 m2_3831_6956# m2_4151_6956# 0.158f
C282 Vo_STG1 xr.vgps 2.10199f
C283 mp_dz m3_14806_950# 0.16458f
C284 m2_10720_9278# mp_dz 3.05025f
C285 xs.o1 VDD 2.18553f
C286 rhigh_37/a_0_0# VDD 0.02277f
C287 rhigh_26/a_0_0# VCTRLN 0.01642f
C288 mn_dz xs.z 0.71258f
C289 Vo_STG1 mn_dz 0.70931f
C290 VCTRLP x1.vcmfb 0.69724f
C291 rhigh_0/a_0_0# rhigh_1/a_0_0# 0.23988f
C292 xr.z VCTRLN 1.24744f
C293 minus x1.vcmfb 0.12764f
C294 rhigh_32/a_0_0# rhigh_31/a_0_0# 0.23988f
C295 Vo1n rhigh_43/a_0_0# 0.01098f
C296 rhigh_49/a_0_0# xr.z 0.02452f
C297 m2_10843_5114# xr.o1 0.03537f
C298 xr.z V1_CM 0.14764f
C299 rhigh_58/a_0_0# VDD 0.02056f
C300 VCTRLP VDD 10.0711f
C301 m2_11483_5114# xs.o1 0.21256f
C302 vtrip x1.vcmfb 1.39869f
C303 rhigh_54/a_0_0# rhigh_55/a_0_0# 0.23988f
C304 a_8611_8716# xr.o1 0.23658f
C305 m2_15963_4634# m3_14806_950# 0.04079f
C306 minus VDD 4.22239f
C307 irn m2_14683_4826# 0.03624f
C308 m2_4846_2504# xr.z 0.01553f
C309 xs.o1 xs.VSV 0.10989f
C310 xr.z m2_13883_2408# 0.02205f
C311 m2_4791_6956# m2_4471_6956# 0.158f
C312 vtrip VDD 2.11166f
C313 m2_3831_6956# xr.z 0.02768f
C314 m2_11163_5114# xr.z 0.0253f
C315 m2_4951_4826# m2_5271_4826# 0.23974f
C316 rhigh_30/a_0_0# xr.z 0.01734f
C317 a_8611_8716# a_9726_6394# 0.02488f
C318 Vo1n it1 1.36089f
C319 VDD rhigh_60/a_0_0# 0.02056f
C320 VCTRLP xs.VSV 0.02381f
C321 xr.o1 xr.vgps 0.12069f
C322 m2_13723_4826# m2_13403_4826# 0.19121f
C323 rhigh_61/a_0_0# rhigh_62/a_0_0# 0.23988f
C324 xs.o1 nlo 0.94528f
C325 minus xs.VSV 0.01538f
C326 IBIAS xs.VSV 0.04344f
C327 rhigh_37/a_0_0# rhigh_38/a_0_0# 0.23988f
C328 irn m2_15323_4634# 0.01283f
C329 m2_12763_4826# VCTRLP 0.01072f
C330 mp_dz m2_11323_2792# 0.18217f
C331 rhigh_56/a_0_0# VDD 0.02056f
C332 vtrip xs.VSV 0.06159f
C333 m2_13723_4826# xr.vgps 0.21031f
C334 m2_14203_2696# xs.VSV 0.01125f
C335 a_9726_6394# xr.vgps 0.02169f
C336 m2_14843_2504# m2_14638_2504# 0.04628f
C337 VCTRLP nlo 0.14282f
C338 m2_12443_4826# m3_14806_950# 0.19898f
C339 rhigh_29/a_0_0# rhigh_28/a_0_0# 0.23988f
C340 minus nlo 0.06619f
C341 nlo IBIAS 8.37951f
C342 plus m2_6551_4826# 0.03992f
C343 rhigh_32/a_0_0# rhigh_33/a_0_0# 0.23988f
C344 minus rhigh_38/a_0_0# 0.0261f
C345 plus m2_6391_7436# 0.03616f
C346 m2_14363_4826# xr.vgps 0.21031f
C347 xr.z rhigh_51/a_0_0# 0.02452f
C348 irn m3_14806_950# 2.16083f
C349 vtrip nlo 1.03823f
C350 xr.z m2_13563_2792# 0.01019f
C351 m2_10786_9662# m2_2104_7148# 0.02904f
C352 m2_11003_2408# IBIAS 0.01742f
C353 m2_1751_4634# VDD 0.08871f
C354 irn a_8594_6394# 0.03224f
C355 m2_2987_2696# a_8594_6394# 0.04522f
C356 m2_10843_5114# xr.z 0.05226f
C357 rhigh_42/a_0_0# xr.z 0.02452f
C358 rhigh_19/a_0_0# rhigh_20/a_0_0# 0.23988f
C359 m2_11643_2792# nlo 0.01107f
C360 m2_8707_2888# VCTRLN 3.83507f
C361 m2_4631_4730# m2_4951_4826# 0.22467f
C362 m2_15963_4634# m2_15643_4634# 0.1299f
C363 VDD rhigh_50/a_0_0# 0.02056f
C364 m2_2231_6956# xr.z 0.0276f
C365 m2_14638_2504# m2_15114_2504# 0.01092f
C366 xr.z a_8611_8716# 1.18838f
C367 Vo1n irn 0.01794f
C368 rhigh_0/a_0_0# xs.z 0.03232f
C369 m2_14683_4826# xs.VSV 0.01548f
C370 m2_8707_2888# m2_13883_2408# 0.04422f
C371 xr.z m2_3031_4634# 0.0549f
C372 m2_6391_7436# V1_CM 0.17192f
C373 m2_12123_4826# m2_11803_4826# 0.19121f
C374 m2_4370_2504# nlo 0.01462f
C375 m2_2104_7148# xs.o1 0.11316f
C376 rhigh_35/a_0_0# xr.z 0.03623f
C377 xr.z xr.vgps 0.43301f
C378 irn m2_13083_4826# 0.03124f
C379 m2_14203_2696# m2_14523_2696# 0.20653f
C380 xr.z m2_4311_4730# 0.05057f
C381 VCTRLP m2_12283_2792# 0.01685f
C382 plus V1_CM 0.0214f
C383 rhigh_8/a_0_0# rhigh_9/a_0_0# 0.23988f
C384 x1.vcmfb a_8594_6394# 0.01984f
C385 xr.z mn_dz 0.02607f
C386 mp_dz xs.z 1.24236f
C387 m2_3191_6956# xr.z 0.02738f
C388 m3_14806_950# VDD 4.83115f
C389 Vo_STG1 mp_dz 0.23895f
C390 VCTRLP m2_2104_7148# 2.83502f
C391 m2_10720_9278# VDD 0.07126f
C392 m2_5751_6956# VDD 0.0483f
C393 minus m2_2104_7148# 0.01538f
C394 rhigh_41/a_0_0# VDD 0.0207f
C395 m3_7171_1046# it1 0.45767f
C396 a_8594_6394# VDD 1.19123f
C397 vtrip m2_2104_7148# 5.35703f
C398 Vo1n x1.vcmfb 1.09881f
C399 Vo_STG1 it1 5.78438f
C400 m2_2391_4634# m2_2711_4634# 0.30104f
C401 VDD m2_2711_4634# 0.08627f
C402 xr.z m2_2871_6956# 0.02916f
C403 rhigh_55/a_0_0# rhigh_56/a_0_0# 0.23988f
C404 m3_14806_950# xs.VSV 3.92082f
C405 m2_8707_2888# m2_13563_2792# 0.21045f
C406 xr.z m2_5911_4826# 0.04464f
C407 irn m2_11803_4826# 0.03124f
C408 m2_15963_4634# xs.z 0.02398f
C409 rhigh_28/a_0_0# xr.z 0.01334f
C410 m2_5751_6956# xs.VSV 0.20999f
C411 VCTRLN V1_CM 0.04418f
C412 Vo1n VDD 1.29617f
C413 m2_10786_9662# xs.o1 0.01142f
C414 m2_4151_6956# m2_4471_6956# 0.158f
C415 rhigh_57/a_0_0# rhigh_58/a_0_0# 0.23988f
C416 rhigh_26/a_0_0# rhigh_27/a_0_0# 0.23988f
C417 m2_12763_4826# m3_14806_950# 0.19641f
C418 m2_3511_6956# xr.z 0.02916f
C419 a_8594_6394# xs.VSV 0.04313f
C420 xr.z m2_12923_2408# 0.01977f
C421 m2_13883_2408# VCTRLN 0.04544f
C422 rhigh_48/a_0_0# xr.z 0.02452f
C423 rhigh_27/a_0_0# xr.z 0.01275f
C424 VDD rhigh_62/a_0_0# 0.02056f
C425 m3_14806_950# nlo 0.08039f
C426 m2_11163_5114# VCTRLN 0.02474f
C427 rhigh_30/a_0_0# VCTRLN 0.02568f
C428 VCTRLP m2_10786_9662# 0.09888f
C429 m2_3894_2504# xr.z 0.01664f
C430 rhigh_4/a_0_0# rhigh_5/a_0_0# 0.23988f
C431 Vo1n xs.VSV 0.02173f
C432 xr.z m2_14843_2504# 0.01773f
C433 a_8594_6394# nlo 2.47172f
C434 rhigh_16/a_0_0# rhigh_17/a_0_0# 0.23988f
C435 m2_13723_4826# mp_dz 0.01227f
C436 it1 xr.o1 0.08202f
C437 m2_3160_12842# m3_7171_1046# 0.09995f
C438 m2_8707_2888# xr.vgps 0.17227f
C439 Vo1n nlo 0.04556f
C440 rhigh_57/a_0_0# rhigh_56/a_0_0# 0.23988f
C441 irn m3_7171_1046# 0.04181f
C442 m2_3031_4634# m2_3351_4634# 0.30104f
C443 xr.z m2_4471_6956# 0.0289f
C444 Vo1n rhigh_38/a_0_0# 0.01078f
C445 m2_6551_4826# xr.vgps 0.1817f
C446 rhigh_7/a_0_0# m3_14806_950# 0.01543f
C447 plus a_8611_8716# 0.0323f
C448 rhigh_13/a_0_0# rhigh_14/a_0_0# 0.23988f
C449 irn Vo_STG1 0.01974f
C450 irn xs.z 0.94019f
C451 rhigh_36/a_0_0# m3_7171_1046# 0.0137f
C452 m2_12123_4826# xr.o1 0.09251f
C453 m2_4791_6956# VDD 0.04823f
C454 m2_6231_4826# xr.z 0.0343f
C455 xr.z m2_13243_2792# 0.01002f
C456 m2_13563_2792# VCTRLN 0.04544f
C457 m2_13083_4826# m2_12763_4826# 0.19121f
C458 VCTRLP xs.o1 0.07697f
C459 rhigh_47/a_0_0# rhigh_48/a_0_0# 0.23988f
C460 xs.o1 IBIAS 0.06315f
C461 m3_14806_950# m2_14523_2696# 0.01129f
C462 m2_1751_4634# m2_2071_4634# 0.30104f
C463 m2_3991_4730# m2_3671_4634# 0.25533f
C464 rhigh_34/a_0_0# xr.z 0.03585f
C465 m2_1431_4634# VDD 0.0964f
C466 rhigh_44/a_0_0# xr.z 0.02452f
C467 plus xr.vgps 0.01739f
C468 m2_10843_5114# VCTRLN 0.02363f
C469 vtrip xs.o1 0.26745f
C470 m2_13563_2792# m2_13883_2408# 0.16082f
C471 m2_11483_5114# m2_11803_4826# 0.17561f
C472 rhigh_4/a_0_0# xr.vgps 0.02398f
C473 m2_15003_4826# xr.vgps 0.22063f
C474 m2_4791_6956# xs.VSV 0.20999f
C475 VCTRLP minus 0.02524f
C476 VCTRLP IBIAS 0.19183f
C477 rhigh_41/a_0_0# rhigh_40/a_0_0# 0.23988f
C478 minus IBIAS 0.11635f
C479 rhigh_43/a_0_0# xr.z 0.02452f
C480 m2_10720_9278# m2_2104_7148# 0.01743f
C481 rhigh_13/a_0_0# rhigh_12/a_0_0# 0.23988f
C482 VCTRLP vtrip 1.52876f
C483 m2_11323_2792# m2_11003_2408# 0.16082f
C484 m2_8707_2888# m2_12923_2408# 0.03999f
C485 m3_7171_1046# x1.vcmfb 3.5565f
C486 m2_3160_12842# xr.o1 0.03435f
C487 m2_5322_2504# a_8594_6394# 0.14002f
C488 minus vtrip 0.02122f
C489 m2_2104_7148# a_8594_6394# 0.04054f
C490 xr.z mp_dz 0.22625f
C491 Vo_STG1 x1.vcmfb 0.07606f
C492 m2_10843_5114# m2_11163_5114# 0.28316f
C493 irn xr.o1 0.04487f
C494 VCTRLN xr.vgps 0.16612f
C495 rhigh_39/a_0_0# VDD 0.02179f
C496 xr.z rhigh_61/a_0_0# 0.02452f
C497 m3_7171_1046# VDD 12.45313f
C498 m2_2987_2696# xr.o1 0.03085f
C499 Vo1n rhigh_40/a_0_0# 0.01982f
C500 m2_8707_2888# m2_14843_2504# 0.04422f
C501 xr.z m2_3991_4730# 0.05334f
C502 Vo_STG1 VDD 4.47472f
C503 xs.z VDD 3.64502f
C504 m2_3418_2408# nlo 0.02809f
C505 m2_5431_6956# VDD 0.04824f
C506 rhigh_59/a_0_0# VDD 0.02056f
C507 rhigh_46/a_0_0# xr.z 0.02452f
C508 xr.z it1 0.93991f
C509 irn m2_13723_4826# 0.03124f
C510 Vo1n m2_2104_7148# 0.02378f
C511 irn a_9726_6394# 0.02115f
C512 rhigh_3/a_0_0# rhigh_4/a_0_0# 0.23988f
C513 rhigh_2/a_0_0# vtrip 0.01583f
C514 mn_dz V1_CM 0.0283f
C515 m2_11163_5114# xr.vgps 0.0316f
C516 xr.z m2_2551_6956# 0.02916f
C517 m2_11483_5114# Vo_STG1 0.04071f
C518 m3_7171_1046# xs.VSV 0.02327f
C519 irn m2_14363_4826# 0.03124f
C520 xs.VSV m2_14638_2504# 0.15036f
C521 irn m2_3671_4634# 0.02252f
C522 xs.z xs.VSV 0.44309f
C523 Vo_STG1 xs.VSV 0.02315f
C524 m2_5431_6956# xs.VSV 0.20999f
C525 xr.z m2_5591_4826# 0.04531f
C526 m2_8707_2888# m2_13243_2792# 0.21045f
C527 rhigh_28/a_0_0# VCTRLN 0.02051f
C528 m2_6551_4826# m2_6231_4826# 0.23974f
C529 m3_7171_1046# nlo 0.09711f
C530 m2_8707_2888# m2_15114_2504# 0.01094f
C531 rhigh_52/a_0_0# xr.z 0.02452f
C532 x1.vcmfb xr.o1 0.03223f
C533 rhigh_38/a_0_0# rhigh_39/a_0_0# 0.23988f
C534 xr.z m2_11963_2408# 0.02425f
C535 nlo m2_14638_2504# 0.01657f
C536 m2_12923_2408# VCTRLN 0.04544f
C537 xs.z nlo 0.107f
C538 Vo_STG1 nlo 1.87846f
C539 rhigh_5/a_0_0# xr.vgps 0.01814f
C540 rhigh_27/a_0_0# VCTRLN 0.01823f
C541 m2_5111_6956# VDD 0.04823f
C542 rhigh_48/a_0_0# rhigh_49/a_0_0# 0.23988f
C543 xr.o1 VDD 1.4517f
C544 rhigh_24/a_0_0# VCTRLP 0.01557f
C545 rhigh_53/a_0_0# rhigh_52/a_0_0# 0.23988f
C546 rhigh_46/a_0_0# rhigh_47/a_0_0# 0.23988f
C547 rhigh_66/a_0_0# VDD 0.02361f
C548 m2_14843_2504# VCTRLN 0.04544f
C549 m2_3160_12842# xr.z 0.04827f
C550 m3_14806_950# xs.o1 2.27094f
C551 a_9726_6394# VDD 1.06183f
C552 irn xr.z 0.45062f
C553 m2_3831_6956# m2_3511_6956# 0.158f
C554 m2_11483_5114# xr.o1 0.06135f
C555 mp_dz m2_8707_2888# 0.51213f
C556 m2_2987_2696# xr.z 0.21356f
C557 m2_10843_5114# xr.vgps 0.0351f
C558 m2_5111_6956# xs.VSV 0.20999f
C559 xr.z m2_15163_2696# 0.02534f
C560 xr.o1 xs.VSV 0.07508f
C561 rhigh_36/a_0_0# xr.z 0.03538f
C562 rhigh_65/a_0_0# VDD 0.02083f
C563 VCTRLP m3_14806_950# 0.13631f
C564 m2_3671_4634# VDD 0.08627f
C565 m2_4151_6956# VDD 0.04823f
C566 m2_10720_9278# VCTRLP 0.02504f
C567 m3_14806_950# IBIAS 0.05238f
C568 m2_13403_4826# xr.vgps 0.21031f
C569 xr.z m2_12603_2792# 0.01146f
C570 a_9726_6394# xs.VSV 0.03769f
C571 m2_13243_2792# VCTRLN 0.04544f
C572 m2_14523_2696# m2_14638_2504# 0.01223f
C573 xr.o1 nlo 1.28984f
C574 vtrip m3_14806_950# 0.16798f
C575 minus a_8594_6394# 0.0228f
C576 a_8594_6394# IBIAS 0.23957f
C577 rhigh_39/a_0_0# rhigh_40/a_0_0# 0.23988f
C578 m2_14363_4826# xs.VSV 0.01678f
C579 rhigh_68/a_0_0# VDD 0.02505f
C580 vtrip a_8594_6394# 0.28378f
C581 m2_4151_6956# xs.VSV 0.20999f
C582 m3_7171_1046# m2_2104_7148# 0.02327f
C583 a_9726_6394# nlo 0.27907f
C584 mn_dz Vout 0.03472f
C585 m2_14043_4826# m3_14806_950# 0.20702f
C586 rhigh_45/a_0_0# xr.z 0.02452f
C587 xr.z x1.vcmfb 1.61884f
C588 m2_2104_7148# xs.z 0.52124f
C589 Vo_STG1 m2_2104_7148# 0.13555f
C590 plus it1 0.17715f
C591 Vo1n minus 0.81207f
C592 rhigh_10/a_0_0# rhigh_9/a_0_0# 0.23988f
C593 xr.z m2_2391_4634# 0.05525f
C594 rhigh_13/a_0_0# mp_dz 0.01209f
C595 Vo1n vtrip 0.01507f
C596 m2_8707_2888# m2_11963_2408# 0.03999f
C597 rhigh_25/a_0_0# VCTRLP 0.01294f
C598 xr.z VDD 7.63738f
C599 mp_dz VCTRLN 0.06303f
C600 rhigh_1/a_0_0# vtrip 0.01325f
C601 mp_dz V1_CM 0.02007f
C602 rhigh_63/a_0_0# VDD 0.02056f
C603 m2_5911_4826# xr.vgps 0.18184f
C604 rhigh_53/a_0_0# VDD 0.02056f
C605 m2_4370_2504# a_8594_6394# 0.14002f
C606 m2_14683_4826# m3_14806_950# 0.22213f
C607 mp_dz m2_13883_2408# 0.01178f
C608 irn m2_8707_2888# 0.02268f
C609 m2_3191_6956# m2_2871_6956# 0.158f
C610 xr.z xs.VSV 0.50085f
C611 rhigh_1/a_0_0# rhigh_2/a_0_0# 0.23988f
C612 m2_15030_12842# Vout 0.02246f
C613 m2_13243_2792# m2_13563_2792# 0.17588f
C614 m2_8707_2888# m2_15163_2696# 0.10149f
C615 m2_5322_2504# xr.o1 0.0119f
C616 irn rhigh_8/a_0_0# 0.01246f
C617 rhigh_23/a_0_0# VCTRLP 0.01814f
C618 Vo_STG1 m2_10786_9662# 0.16655f
C619 m2_10786_9662# xs.z 0.08661f
C620 m2_2104_7148# xr.o1 0.05066f
C621 m2_15643_4634# vtrip 0.01396f
C622 m2_3191_6956# m2_3511_6956# 0.158f
C623 m2_14843_2504# xr.vgps 0.01078f
C624 xr.z nlo 2.11745f
C625 m2_1911_6956# xr.z 0.02782f
C626 m2_15323_4634# m3_14806_950# 0.01507f
C627 rhigh_38/a_0_0# xr.z 0.01683f
C628 xr.z m2_5271_4826# 0.04546f
C629 m2_11323_2792# m2_11643_2792# 0.17588f
C630 m2_8707_2888# m2_12603_2792# 0.21045f
C631 rhigh_47/a_0_0# VDD 0.02056f
C632 irn plus 0.03547f
C633 m2_2104_7148# a_9726_6394# 0.03505f
C634 xr.z m2_11003_2408# 0.05985f
C635 m2_11963_2408# VCTRLN 0.0494f
C636 rhigh_36/a_0_0# plus 0.01689f
C637 irn m2_15003_4826# 0.04699f
C638 rhigh_14/a_0_0# mp_dz 0.01477f
C639 mp_dz m2_13563_2792# 0.07953f
C640 rhigh_27/a_0_0# rhigh_28/a_0_0# 0.23988f
C641 m2_6231_4826# xr.vgps 0.1817f
C642 rhigh_18/a_0_0# rhigh_19/a_0_0# 0.23988f
C643 rhigh_43/a_0_0# rhigh_42/a_0_0# 0.23988f
C644 xs.o1 xs.z 0.22763f
C645 Vo_STG1 xs.o1 0.20099f
C646 rhigh_35/a_0_0# rhigh_34/a_0_0# 0.23988f
C647 xr.vgps m2_15114_2504# 0.01878f
C648 m2_6391_7436# x1.vcmfb 0.29708f
C649 irn VCTRLN 0.0498f
C650 m2_3160_12842# V1_CM 0.01433f
C651 rhigh_24/a_0_0# rhigh_25/a_0_0# 0.23988f
C652 VCTRLP m3_7171_1046# 2.54381f
C653 rhigh_67/a_0_0# VDD 0.02424f
C654 m2_6551_4826# VDD 0.07591f
C655 rhigh_32/a_0_0# xr.z 0.02966f
C656 minus rhigh_39/a_0_0# 0.01655f
C657 xr.z m2_14523_2696# 0.01836f
C658 m2_1591_6956# xr.z 0.03271f
C659 m2_6391_7436# VDD 0.04851f
C660 m3_7171_1046# IBIAS 0.55195f
C661 m2_15163_2696# VCTRLN 0.04544f
C662 minus m3_7171_1046# 0.13339f
C663 VCTRLP xs.z 0.60839f
C664 Vo_STG1 VCTRLP 6.18509f
C665 rhigh_58/a_0_0# rhigh_59/a_0_0# 0.23988f
C666 Vo_STG1 minus 0.05872f
C667 plus x1.vcmfb 1.49554f
C668 m2_13403_4826# mp_dz 0.03203f
C669 m2_3351_4634# VDD 0.08627f
C670 rhigh_55/a_0_0# xr.z 0.02452f
C671 vtrip m3_7171_1046# 0.02344f
C672 rhigh_14/a_0_0# rhigh_15/a_0_0# 0.23988f
C673 m2_4631_4730# xr.z 0.05222f
C674 xr.z rhigh_40/a_0_0# 0.02381f
C675 Vo1n rhigh_41/a_0_0# 0.01615f
C676 m2_8707_2888# xs.VSV 0.04617f
C677 Vo_STG1 vtrip 0.02602f
C678 vtrip xs.z 1.18825f
C679 xr.z m2_12283_2792# 0.01241f
C680 rhigh_68/a_0_0# rhigh_69/a_0_0# 0.23988f
C681 m2_12603_2792# VCTRLN 0.04544f
C682 irn m2_11163_5114# 0.03124f
C683 mp_dz Vout 0.08891f
C684 it1 a_8611_8716# 0.07599f
C685 Vo1n a_8594_6394# 0.22385f
C686 plus VDD 4.97871f
C687 m2_5322_2504# xr.z 0.01504f
C688 m2_6231_4826# m2_5911_4826# 0.23974f
C689 mp_dz xr.vgps 0.02402f
C690 xr.z m2_2104_7148# 0.36183f
C691 m2_1431_4634# m2_1751_4634# 0.30104f
C692 m2_15643_4634# m2_15323_4634# 0.1299f
C693 m2_6391_7436# xs.VSV 0.03128f
C694 rhigh_52/a_0_0# rhigh_51/a_0_0# 0.23988f
C695 rhigh_59/a_0_0# rhigh_60/a_0_0# 0.23988f
C696 rhigh_54/a_0_0# xr.z 0.02452f
C697 m2_13083_4826# m3_14806_950# 0.21608f
C698 rhigh_31/a_0_0# xr.z 0.02966f
C699 m2_2231_6956# m2_2551_6956# 0.158f
C700 rhigh_24/a_0_0# rhigh_23/a_0_0# 0.23988f
C701 rhigh_2/a_0_0# xs.z 0.01066f
C702 m2_8707_2888# nlo 0.04804f
C703 m2_13243_2792# m2_12923_2408# 0.16082f
C704 mn_dz mp_dz 0.26042f
C705 xr.o1 xs.o1 2.6959f
C706 rhigh_69/a_0_0# xr.z 0.03113f
C707 m2_3991_4730# m2_4311_4730# 0.27039f
C708 rhigh_19/a_0_0# mp_dz 0.01212f
C709 plus xs.VSV 0.0172f
C710 irn rhigh_5/a_0_0# 0.01576f
C711 rhigh_64/a_0_0# rhigh_65/a_0_0# 0.23988f
C712 rhigh_53/a_0_0# rhigh_54/a_0_0# 0.23988f
C713 x1.vcmfb V1_CM 0.01967f
C714 m2_15643_4634# m3_14806_950# 0.04431f
C715 xr.z m2_2071_4634# 0.05621f
C716 rhigh_21/a_0_0# VCTRLP 0.0164f
C717 m2_8707_2888# m2_11003_2408# 0.04793f
C718 a_9726_6394# xs.o1 0.36881f
C719 VCTRLP xr.o1 0.07742f
C720 VCTRLN VDD 0.36863f
C721 m2_12123_4826# xr.vgps 0.21031f
C722 xr.o1 IBIAS 0.21756f
C723 m2_14843_2504# m2_15114_2504# 0.04964f
C724 rhigh_57/a_0_0# xr.z 0.02452f
C725 rhigh_49/a_0_0# VDD 0.02056f
C726 minus xr.o1 0.05935f
C727 VDD V1_CM 1.81849f
C728 plus nlo 0.06818f
C729 rhigh_11/a_0_0# rhigh_12/a_0_0# 0.23988f
C730 m2_14363_4826# xs.o1 0.01306f
C731 vtrip xr.o1 0.03934f
C732 m2_5591_4826# xr.vgps 0.18184f
C733 rhigh_13/a_0_0# xs.VSV 0.01037f
C734 xr.z m2_10786_9662# 0.06522f
C735 mp_dz m2_12923_2408# 0.05108f
C736 irn m2_10843_5114# 0.03475f
C737 m2_3831_6956# VDD 0.04823f
C738 m2_3160_12842# a_8611_8716# 0.09483f
C739 m2_11163_5114# VDD 0.20954f
C740 VCTRLN xs.VSV 0.06542f
C741 rhigh_7/a_0_0# rhigh_8/a_0_0# 0.23988f
C742 vtrip a_9726_6394# 0.27829f
C743 rhigh_20/a_0_0# VCTRLP 0.01396f
C744 m2_8707_2888# m2_14523_2696# 0.1012f
C745 xs.VSV V1_CM 5.22112f
C746 m2_3418_2408# a_8594_6394# 0.04954f
C747 rhigh_33/a_0_0# xr.z 0.03747f
C748 m2_2551_6956# m2_2871_6956# 0.158f
C749 irn m2_13403_4826# 0.03124f
C750 m2_12443_4826# xr.vgps 0.21031f
C751 m2_13883_2408# xs.VSV 0.01096f
C752 rhigh_64/a_0_0# xr.z 0.02452f
C753 m2_11483_5114# m2_11163_5114# 0.28316f
C754 nlo VCTRLN 1.33061f
C755 m2_14043_4826# m2_13723_4826# 0.19121f
C756 irn Vout 0.50354f
C757 xr.z m2_4951_4826# 0.0461f
C758 m2_8707_2888# m2_12283_2792# 0.21045f
C759 m2_3831_6956# xs.VSV 0.20999f
C760 irn xr.vgps 8.69552f
C761 rhigh_18/a_0_0# mp_dz 0.0148f
C762 nlo V1_CM 0.04239f
C763 rhigh_9/a_0_0# xs.VSV 0.02344f
C764 m2_5591_4826# m2_5911_4826# 0.23974f
C765 rhigh_64/a_0_0# rhigh_63/a_0_0# 0.23988f
C766 irn m2_4311_4730# 0.18497f
C767 m2_4846_2504# nlo 0.01462f
C768 m2_15163_2696# xr.vgps 0.21094f
C769 xr.z xs.o1 1.84253f
C770 m2_11003_2408# VCTRLN 0.06914f
C771 m2_13883_2408# nlo 0.10369f
C772 rhigh_37/a_0_0# xr.z 0.01522f
C773 m2_14043_4826# m2_14363_4826# 0.19121f
C774 irn mn_dz 0.08565f
C775 VDD rhigh_51/a_0_0# 0.02056f
C776 m2_6391_7436# m2_2104_7148# 0.03412f
C777 Vo_STG1 m3_14806_950# 0.01806f
C778 m3_14806_950# xs.z 0.5014f
C779 rhigh_43/a_0_0# rhigh_44/a_0_0# 0.23988f
C780 m2_10720_9278# xs.z 0.06965f
C781 Vo_STG1 m2_10720_9278# 0.75558f
C782 m2_5431_6956# m2_5751_6956# 0.158f
C783 mp_dz m2_13243_2792# 0.19436f
C784 VCTRLP rhigh_26/a_0_0# 0.01035f
C785 m3_7171_1046# a_8594_6394# 0.20737f
C786 Vo_STG1 a_8594_6394# 0.01262f
C787 rhigh_58/a_0_0# xr.z 0.02452f
C788 VCTRLP xr.z 0.24454f
C789 x1.vcmfb a_8611_8716# 0.72391f
C790 xr.z IBIAS 0.7875f
C791 rhigh_42/a_0_0# VDD 0.02067f
C792 m2_10843_5114# VDD 0.20961f
C793 minus xr.z 1.83885f
C794 plus m2_2104_7148# 0.0172f
C795 rhigh_22/a_0_0# VCTRLP 0.02335f
C796 Vo1n rhigh_39/a_0_0# 0.01897f
C797 m2_2231_6956# VDD 0.04823f
C798 Vo1n m3_7171_1046# 0.08382f
C799 a_8611_8716# VDD 0.55009f
C800 vtrip xr.z 0.23329f
C801 xr.z m2_14203_2696# 0.02124f
C802 rhigh_32/a_0_0# VCTRLN 0.01903f
C803 m2_14523_2696# VCTRLN 0.04544f
C804 m2_14363_4826# m2_14683_4826# 0.19121f
C805 Vo1n Vo_STG1 6.17141f
C806 xr.z rhigh_60/a_0_0# 0.02452f
C807 m2_3031_4634# VDD 0.08627f
C808 rhigh_1/a_0_0# xs.z 0.01151f
C809 Vout VDD 0.69635f
C810 rhigh_2/a_0_0# xr.z 0.01424f
C811 xr.z m2_11643_2792# 0.01446f
C812 m2_12283_2792# VCTRLN 0.04694f
C813 m2_13563_2792# nlo 0.01136f
C814 xr.vgps VDD 0.05495f
C815 m2_2231_6956# xs.VSV 0.20999f
C816 rhigh_56/a_0_0# xr.z 0.02452f
C817 rhigh_10/a_0_0# rhigh_11/a_0_0# 0.23988f
C818 m3_14806_950# xr.o1 0.21843f
C819 m2_2104_7148# VCTRLN 0.04239f
C820 m2_4311_4730# VDD 0.08903f
C821 irn m2_14843_2504# 0.02713f
C822 rhigh_5/a_0_0# rhigh_6/a_0_0# 0.23988f
C823 mn_dz VDD 2.86375f
C824 m2_3191_6956# VDD 0.04823f
C825 m2_2104_7148# V1_CM 0.50364f
C826 rhigh_31/a_0_0# VCTRLN 0.0292f
C827 m2_12603_2792# m2_12923_2408# 0.16082f
C828 m2_15163_2696# m2_14843_2504# 0.19147f
C829 xr.o1 a_8594_6394# 0.0573f
C830 m2_4846_2504# m2_5322_2504# 0.01927f
C831 m2_11483_5114# xr.vgps 0.03573f
C832 rhigh_12/a_0_0# xs.VSV 0.01296f
C833 m2_4370_2504# xr.z 0.01548f
C834 m2_13723_4826# m3_14806_950# 0.18382f
C835 a_8611_8716# nlo 0.26882f
C836 m2_2231_6956# m2_1911_6956# 0.158f
C837 xs.VSV xr.vgps 0.14685f
C838 xr.z m2_1751_4634# 0.05621f
C839 rhigh_15/a_0_0# mp_dz 0.01695f
C840 m2_8707_2888# xs.o1 0.06593f
C841 a_9726_6394# a_8594_6394# 0.11503f
C842 VDD m2_2871_6956# 0.04823f
C843 Vo1n xr.o1 0.02189f
C844 m2_12763_4826# xr.vgps 0.21031f
C845 m2_14363_4826# m3_14806_950# 0.18185f
C846 m2_3191_6956# xs.VSV 0.20999f
C847 m2_5911_4826# VDD 0.09349f
C848 rhigh_30/a_0_0# rhigh_31/a_0_0# 0.23988f
C849 nlo xr.vgps 0.04841f
C850 xr.z rhigh_50/a_0_0# 0.02452f
C851 m2_5271_4826# xr.vgps 0.18391f
C852 VCTRLP m2_8707_2888# 0.02632f
C853 m2_3511_6956# VDD 0.04823f
C854 Vo1n a_9726_6394# 0.05071f
C855 rhigh_48/a_0_0# VDD 0.02056f
C856 rhigh_24/a_0_0# xr.z 0.01072f
C857 mp_dz m2_11963_2408# 0.04512f
C858 m2_15163_2696# m2_15114_2504# 0.01179f
C859 mn_dz nlo 0.03839f
C860 xs.VSV m2_2871_6956# 0.20999f
C861 m2_15030_12842# VDD 1.06319f
C862 plus rhigh_37/a_0_0# 0.02759f
C863 m2_10786_9662# V1_CM 0.03257f
C864 vtrip m2_8707_2888# 0.02414f
C865 minus m2_6391_7436# 0.0357f
C866 m2_8707_2888# m2_14203_2696# 0.1012f
C867 rhigh_6/a_0_0# xr.vgps 0.01557f
C868 rhigh_33/a_0_0# VCTRLN 0.0159f
C869 vtrip m2_6391_7436# 0.26766f
C870 m2_3511_6956# xs.VSV 0.20999f
C871 VCTRLP plus 0.02398f
C872 irn mp_dz 0.61424f
C873 xr.z m3_14806_950# 0.06091f
C874 plus IBIAS 0.10481f
C875 m2_8707_2888# m2_11643_2792# 0.21045f
C876 minus plus 13.5294f
C877 m2_10720_9278# xr.z 0.03779f
C878 m2_5751_6956# xr.z 0.0276f
C879 rhigh_41/a_0_0# xr.z 0.02452f
C880 Vo_STG1 m3_7171_1046# 0.05232f
C881 m2_5111_6956# m2_4791_6956# 0.158f
C882 VDD m2_4471_6956# 0.04823f
C883 VDD GND 19.00208f
C884 xr.vgps GND 1.34082f
C885 xs.VSV GND 1.48266f
C886 IBIAS GND 17.42924f
C887 VCTRLN GND 3.45355f
C888 nlo GND 24.78872f
C889 xs.z GND 1.79317f
C890 m2_13883_2408# GND 0.20019f
C891 m2_12923_2408# GND 0.11816f
C892 m2_11963_2408# GND 0.11434f
C893 m2_11003_2408# GND 0.22591f
C894 xs.o1 GND 1.38005f
C895 a_8594_6394# GND 2.46874f
C896 m2_14843_2504# GND 0.22334f
C897 m2_15163_2696# GND 0.09072f
C898 m2_14523_2696# GND 0.08906f
C899 m2_14203_2696# GND 0.12276f
C900 xr.o1 GND 5.21535f
C901 m2_13563_2792# GND -0.08865f
C902 m2_13243_2792# GND -0.13264f
C903 m2_12603_2792# GND -0.14133f
C904 m2_12283_2792# GND -0.1331f
C905 m2_11643_2792# GND -0.14114f
C906 m2_11323_2792# GND -0.12876f
C907 a_9726_6394# GND 1.07995f
C908 m2_8707_2888# GND 1.2189f
C909 m2_3671_4634# GND 0.18864f
C910 m2_3351_4634# GND 0.18632f
C911 m2_3031_4634# GND 0.19912f
C912 m2_2391_4634# GND 0.18636f
C913 m2_2071_4634# GND 0.18693f
C914 m2_1751_4634# GND 0.18693f
C915 m2_1431_4634# GND 0.33347f
C916 m2_4311_4730# GND -0.05092f
C917 m2_3991_4730# GND -0.02689f
C918 m2_5911_4826# GND -0.07455f
C919 m2_5591_4826# GND -0.07481f
C920 m2_5271_4826# GND -0.07648f
C921 m2_4951_4826# GND -0.08231f
C922 m3_14806_950# GND 6.82321f
C923 m2_2104_7148# GND 10.47178f
C924 a_8611_8716# GND 2.76625f
C925 x1.vcmfb GND 6.38828f
C926 Vout GND 1.26425f
C927 mp_dz GND 6.40944f
C928 mn_dz GND 5.14045f
C929 it1 GND 0.16744f
C930 m2_10786_9662# GND -0.90004f
C931 m3_7171_1046# GND 1.42211f
C932 rhigh_9/a_0_0# GND 0.01082f
C933 m2_14683_4826# GND -0.07773f
C934 rhigh_8/a_0_0# GND 0.01082f
C935 rhigh_7/a_0_0# GND 0.01082f
C936 m2_15003_4826# GND -0.03455f
C937 rhigh_6/a_0_0# GND 0.01082f
C938 rhigh_5/a_0_0# GND 0.01082f
C939 m2_15323_4634# GND 0.07374f
C940 rhigh_4/a_0_0# GND 0.01082f
C941 plus GND -0.59586f
C942 minus GND -0.36802f
C943 rhigh_3/a_0_0# GND 0.0117f
C944 m2_15643_4634# GND 0.07863f
C945 rhigh_2/a_0_0# GND 0.01082f
C946 rhigh_1/a_0_0# GND 0.015f
C947 m2_15963_4634# GND 0.14775f
C948 VCTRLP GND 1.94612f
C949 rhigh_0/a_0_0# GND 0.01502f
C950 m2_10720_9278# GND 0.39085f
C951 m2_3160_12842# GND 0.18613f
C952 m2_5322_2504# GND 0.14121f
C953 m2_4846_2504# GND 0.13018f
C954 m2_4370_2504# GND 0.13091f
C955 m2_3894_2504# GND 0.13159f
C956 m2_3418_2408# GND 0.02328f
C957 m2_2987_2696# GND 1.94459f
C958 rhigh_19/a_0_0# GND 0.01082f
C959 m2_13083_4826# GND -0.08362f
C960 m2_15030_12842# GND -0.17417f
C961 rhigh_18/a_0_0# GND 0.01082f
C962 rhigh_29/a_0_0# GND 0.01216f
C963 m2_11483_5114# GND 0.0323f
C964 irn GND 21.87203f
C965 xr.z GND 5.47404f
C966 rhigh_17/a_0_0# GND 0.01082f
C967 m2_13403_4826# GND -0.07707f
C968 rhigh_28/a_0_0# GND 0.01155f
C969 m2_6231_4826# GND -0.07978f
C970 rhigh_16/a_0_0# GND 0.01082f
C971 rhigh_27/a_0_0# GND 0.01139f
C972 m2_11803_4826# GND -0.07406f
C973 m2_6391_7436# GND 0.12015f
C974 m2_4631_4730# GND -0.0433f
C975 vtrip GND 2.89959f
C976 rhigh_15/a_0_0# GND 0.01082f
C977 m2_13723_4826# GND -0.07509f
C978 rhigh_26/a_0_0# GND 0.01127f
C979 m2_6551_4826# GND 0.02207f
C980 m2_4791_6956# GND 0.0518f
C981 rhigh_14/a_0_0# GND 0.01082f
C982 rhigh_25/a_0_0# GND 0.01082f
C983 m2_12123_4826# GND -0.08044f
C984 m2_3191_6956# GND 0.08169f
C985 rhigh_13/a_0_0# GND 0.01082f
C986 m2_14043_4826# GND -0.08172f
C987 rhigh_24/a_0_0# GND 0.01088f
C988 m2_5111_6956# GND 0.05173f
C989 m2_1591_6956# GND 0.07805f
C990 rhigh_35/a_0_0# GND 0.01392f
C991 Vo1n GND 4.11505f
C992 rhigh_12/a_0_0# GND 0.01082f
C993 rhigh_23/a_0_0# GND 0.01082f
C994 m2_12443_4826# GND -0.07972f
C995 m2_3511_6956# GND 0.05681f
C996 rhigh_34/a_0_0# GND 0.01738f
C997 Vo_STG1 GND 4.23794f
C998 rhigh_11/a_0_0# GND 0.01082f
C999 m2_14363_4826# GND -0.08186f
C1000 rhigh_22/a_0_0# GND 0.01082f
C1001 rhigh_33/a_0_0# GND 0.0235f
C1002 m2_10843_5114# GND 0.13662f
C1003 m2_5431_6956# GND 0.05681f
C1004 m2_1911_6956# GND 0.05003f
C1005 rhigh_10/a_0_0# GND 0.01082f
C1006 rhigh_21/a_0_0# GND 0.01082f
C1007 m2_12763_4826# GND -0.07906f
C1008 rhigh_32/a_0_0# GND 0.01504f
C1009 m2_3831_6956# GND 0.05208f
C1010 m2_2231_6956# GND 0.05003f
C1011 rhigh_20/a_0_0# GND 0.01082f
C1012 rhigh_31/a_0_0# GND 0.01355f
C1013 m2_5751_6956# GND 0.05187f
C1014 rhigh_30/a_0_0# GND 0.0128f
C1015 m2_4151_6956# GND 0.05194f
C1016 V1_CM GND 6.1104f
C1017 m2_2551_6956# GND 0.05681f
C1018 m2_4471_6956# GND 0.05681f
C1019 m2_2711_4634# GND 0.18571f
C1020 m2_2871_6956# GND 0.05681f
C1021 m2_15114_2504# GND 0.11766f
C1022 m2_14638_2504# GND 0.13541f
.ends
