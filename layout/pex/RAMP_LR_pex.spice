* NGSPICE file created from RAMP_LR.ext - technology: ihp-sg13g2

.subckt pc_nmos_2 a_68_n36# sub a_168_0# a_0_0#
X0 a_168_0# a_68_n36# a_0_0# sub sg13_lv_nmos ad=0.5304p pd=3.8u as=0.5304p ps=3.8u w=1.56u l=0.5u
C0 a_68_n36# a_168_0# 0.0291f
C1 a_68_n36# a_0_0# 0.0291f
C2 a_0_0# a_168_0# 0.07402f
C3 a_168_0# sub 0.07249f
C4 a_0_0# sub 0.07249f
C5 a_68_n36# sub 0.16054f
.ends

.subckt pc_pmos_1 a_100_15# w_n62_n62# a_74_n21# sub a_0_0#
X0 a_100_15# a_74_n21# a_0_0# w_n62_n62# sg13_lv_pmos ad=0.1005p pd=1.34u as=0.1005p ps=1.34u w=0.15u l=0.13u
C0 w_n62_n62# a_74_n21# 0.02613f
C1 a_100_15# a_0_0# 0.02238f
C2 a_100_15# sub 0.01942f
C3 a_74_n21# sub 0.02332f
C4 a_0_0# sub 0.01942f
.ends

.subckt pc_pmosHV_1 a_268_0# a_68_n36# w_n124_n124# sub a_0_0#
X0 a_268_0# a_68_n36# a_0_0# w_n124_n124# sg13_hv_pmos ad=0.17p pd=1.68u as=0.17p ps=1.68u w=0.5u l=1u
C0 w_n124_n124# a_0_0# 0.01141f
C1 a_268_0# a_68_n36# 0.01382f
C2 a_268_0# w_n124_n124# 0.01141f
C3 a_268_0# a_0_0# 0.01358f
C4 w_n124_n124# a_68_n36# 0.13348f
C5 a_68_n36# a_0_0# 0.01382f
C6 a_268_0# sub 0.02349f
C7 a_0_0# sub 0.02349f
C8 a_68_n36# sub 0.06285f
.ends

.subckt pc_nmosHV_2 a_268_0# a_68_n36# sub a_0_0#
X0 a_268_0# a_68_n36# a_0_0# sub sg13_hv_nmos ad=0.782p pd=5.28u as=0.782p ps=5.28u w=2.3u l=1u
C0 a_68_n36# a_268_0# 0.06358f
C1 a_68_n36# a_0_0# 0.06358f
C2 a_0_0# a_268_0# 0.06246f
C3 a_268_0# sub 0.10087f
C4 a_0_0# sub 0.10087f
C5 a_68_n36# sub 0.35371f
.ends

.subckt pc_cmim sub c1_0_0# m5_n120_n120#
X0 c1_0_0# m5_n120_n120# cap_cmim l=36.5u w=36.5u
C0 m5_n120_n120# c1_0_0# 2.94342f
C1 c1_0_0# sub 5.2363f
C2 m5_n120_n120# sub 14.2934f
.ends

.subckt pc_pmos_2 a_68_n36# w_n62_n62# sub a_168_0# a_0_0#
X0 a_168_0# a_68_n36# a_0_0# w_n62_n62# sg13_lv_pmos ad=0.408p pd=3.08u as=0.408p ps=3.08u w=1.2u l=0.5u
C0 w_n62_n62# a_0_0# 0.01435f
C1 a_168_0# a_68_n36# 0.02238f
C2 a_168_0# w_n62_n62# 0.01435f
C3 a_168_0# a_0_0# 0.05694f
C4 w_n62_n62# a_68_n36# 0.09187f
C5 a_68_n36# a_0_0# 0.02238f
C6 a_168_0# sub 0.05058f
C7 a_0_0# sub 0.05058f
C8 a_68_n36# sub 0.05293f
.ends

.subckt pc_pmosHV_2 a_68_n36# w_n124_n124# sub a_168_0# a_0_0#
X0 a_168_0# a_68_n36# a_0_0# w_n124_n124# sg13_hv_pmos ad=1.53p pd=9.68u as=1.53p ps=9.68u w=4.5u l=0.5u
C0 w_n124_n124# a_0_0# 0.07584f
C1 a_168_0# a_68_n36# 0.08394f
C2 a_168_0# w_n124_n124# 0.07584f
C3 a_168_0# a_0_0# 0.21362f
C4 w_n124_n124# a_68_n36# 0.25215f
C5 a_68_n36# a_0_0# 0.08394f
C6 a_168_0# sub 0.13645f
C7 a_0_0# sub 0.13645f
C8 a_68_n36# sub 0.03691f
.ends

.subckt pc_nmos a_68_n36# sub a_0_0# a_1668_0#
X0 a_1668_0# a_68_n36# a_0_0# sub sg13_lv_nmos ad=0.17p pd=1.68u as=0.17p ps=1.68u w=0.5u l=8u
C0 a_68_n36# a_1668_0# 0.02075f
C1 a_68_n36# a_0_0# 0.02075f
C2 a_1668_0# sub 0.03407f
C3 a_0_0# sub 0.03407f
C4 a_68_n36# sub 1.3462f
.ends

.subckt pc_nmos_1 a_100_15# a_74_n21# sub a_0_0#
X0 a_100_15# a_74_n21# a_0_0# sub sg13_lv_nmos ad=0.1005p pd=1.34u as=0.1005p ps=1.34u w=0.15u l=0.13u
C0 a_0_0# a_100_15# 0.02238f
C1 a_100_15# sub 0.02279f
C2 a_74_n21# sub 0.04944f
C3 a_0_0# sub 0.02279f
.ends

.subckt pc_nmosHV a_68_n36# sub a_468_0# a_0_0#
X0 a_468_0# a_68_n36# a_0_0# sub sg13_hv_nmos ad=0.17p pd=1.68u as=0.17p ps=1.68u w=0.5u l=2u
C0 a_68_n36# a_468_0# 0.0174f
C1 a_68_n36# a_0_0# 0.0174f
C2 a_468_0# sub 0.03184f
C3 a_0_0# sub 0.03184f
C4 a_68_n36# sub 0.3606f
.ends

.subckt pc_nmosHV_1 a_268_0# a_68_n36# sub a_0_0#
X0 a_268_0# a_68_n36# a_0_0# sub sg13_hv_nmos ad=0.595p pd=4.18u as=0.595p ps=4.18u w=1.75u l=1u
C0 a_68_n36# a_268_0# 0.04837f
C1 a_68_n36# a_0_0# 0.04837f
C2 a_0_0# a_268_0# 0.04752f
C3 a_268_0# sub 0.07978f
C4 a_0_0# sub 0.07978f
C5 a_68_n36# sub 0.30562f
.ends

.subckt pc_rhigh sub a_0_1685# a_0_n86# a_0_0#
X0 a_0_1685# a_0_n86# sub rhigh l=8.425u w=0.5u
C0 a_0_1685# a_0_0# 0.01822f
C1 a_0_0# a_0_n86# 0.01822f
C2 a_0_n86# sub 0.11986f
C3 a_0_0# sub 1.11876f
C4 a_0_1685# sub 0.11986f
.ends

.subckt pc_pmos a_68_n36# w_n62_n62# sub a_0_0# a_1668_0#
X0 a_1668_0# a_68_n36# a_0_0# w_n62_n62# sg13_lv_pmos ad=0.17p pd=1.68u as=0.17p ps=1.68u w=0.5u l=8u
C0 w_n62_n62# a_0_0# 0.0102f
C1 a_1668_0# a_68_n36# 0.02075f
C2 a_1668_0# w_n62_n62# 0.0102f
C3 w_n62_n62# a_68_n36# 0.72028f
C4 a_68_n36# a_0_0# 0.02075f
C5 a_1668_0# sub 0.02968f
C6 a_0_0# sub 0.02968f
C7 a_68_n36# sub 0.62592f
.ends

.subckt pc_pmosHV a_68_n36# w_n124_n124# sub a_218_0# a_0_0#
X0 a_218_0# a_68_n36# a_0_0# w_n124_n124# sg13_hv_pmos ad=0.17p pd=1.68u as=0.17p ps=1.68u w=0.5u l=0.75u
C0 w_n124_n124# a_0_0# 0.01096f
C1 a_218_0# a_68_n36# 0.01199f
C2 a_218_0# w_n124_n124# 0.01096f
C3 a_218_0# a_0_0# 0.01734f
C4 w_n124_n124# a_68_n36# 0.10538f
C5 a_68_n36# a_0_0# 0.01199f
C6 a_218_0# sub 0.02349f
C7 a_0_0# sub 0.02349f
C8 a_68_n36# sub 0.04988f
.ends

.subckt RAMP_LR VDD GND IBIAS minus plus Vout
Xnmos_2_3 a_20592_17400# GND a_19668_25739# icm pc_nmos_2
Xpmos_1_7 V1_CM VDD V1_CM GND m2_1512_35799# pc_pmos_1
XpmosHV_1_2 Vo_STG1 a_21036_25739# VDD GND VDD pc_pmosHV_1
XnmosHV_2_0 GND GND GND GND pc_nmosHV_2
Xnmos_2_4 a_20592_17400# GND a_19668_25739# icm pc_nmos_2
Xcmim_0 GND GND VCTRLN pc_cmim
Xpmos_1_8 m2_924_35079# VDD VCTRLP GND VDD pc_pmos_1
XpmosHV_1_3 a_21036_25739# a_21036_25739# VDD GND VDD pc_pmosHV_1
XnmosHV_2_1 Vout mn_dz GND GND pc_nmosHV_2
Xnmos_2_5 V1_CM GND a_21036_25739# icm pc_nmos_2
Xcmim_1 GND VDD VCTRLP pc_cmim
Xpmos_1_9 m2_924_35079# VDD VCTRLP GND VDD pc_pmos_1
Xnmos_2_10 plus GND Vo_STG1 it1 pc_nmos_2
XnmosHV_2_2 Vout mn_dz GND GND pc_nmosHV_2
XpmosHV_1_4 a_19668_25739# a_19668_25739# VDD GND VDD pc_pmosHV_1
Xnmos_2_6 GND GND GND GND pc_nmos_2
XnmosHV_2_3 irp irp GND GND pc_nmosHV_2
Xnmos_2_11 minus GND m3_14960_18822# it1 pc_nmos_2
XpmosHV_1_5 a_19668_25739# a_19668_25739# VDD GND VDD pc_pmosHV_1
Xnmos_2_7 GND GND GND GND pc_nmos_2
XnmosHV_2_4 Vout mn_dz GND GND pc_nmosHV_2
Xnmos_2_12 GND GND GND GND pc_nmos_2
XpmosHV_1_6 a_21036_25739# a_21036_25739# VDD GND VDD pc_pmosHV_1
Xnmos_2_8 minus GND m3_14960_18822# it1 pc_nmos_2
XpmosHV_1_7 Vo_STG1 a_21036_25739# VDD GND VDD pc_pmosHV_1
XnmosHV_2_5 Vout mn_dz GND GND pc_nmosHV_2
Xnmos_2_9 plus GND Vo_STG1 it1 pc_nmos_2
XpmosHV_1_8 m3_14960_18822# a_21036_25739# VDD GND VDD pc_pmosHV_1
XnmosHV_2_6 GND GND GND GND pc_nmosHV_2
Xpmos_1_20 mp_dz VDD Vo_STG1 GND VDD pc_pmos_1
XpmosHV_1_9 VDD VDD VDD GND VDD pc_pmosHV_1
Xpmos_1_21 m2_1512_35799# VDD GND GND VDD pc_pmos_1
Xpmos_1_10 m2_1512_35799# VDD GND GND VDD pc_pmos_1
Xpmos_1_22 m2_1218_35439# VDD VCTRLP GND VDD pc_pmos_1
Xpmos_1_11 V1_CM VDD V1_CM GND m2_1512_35799# pc_pmos_1
Xpmos_1_23 m2_924_35079# VDD VCTRLP GND VDD pc_pmos_1
Xpmos_1_12 m2_1218_35439# VDD VCTRLP GND VDD pc_pmos_1
Xpmos_2_0 VCTRLP VDD GND VDD VDD pc_pmos_2
Xpmos_1_24 m2_1512_35799# VDD GND GND VDD pc_pmos_1
Xpmos_1_13 m2_924_35079# VDD VCTRLP GND VDD pc_pmos_1
Xpmos_2_1 VDD VDD GND VDD VDD pc_pmos_2
Xpmos_1_25 m2_1218_35439# VDD VCTRLP GND VDD pc_pmos_1
Xpmos_1_14 m2_1512_35799# VDD GND GND VDD pc_pmos_1
Xpmos_2_2 irp VDD GND VCTRLP ipota pc_pmos_2
Xpmos_1_26 m2_924_35079# VDD VCTRLP GND VDD pc_pmos_1
Xpmos_1_15 m2_1218_35439# VDD VCTRLP GND VDD pc_pmos_1
Xpmos_2_3 a_18456_7060# VDD GND m3_16160_800# ipota pc_pmos_2
Xpmos_1_27 m2_1512_35799# VDD GND GND VDD pc_pmos_1
Xpmos_1_16 a_18456_7060# VDD V1_CM GND m2_1218_35439# pc_pmos_1
Xpmos_2_4 a_18456_7060# VDD GND m3_16160_800# ipota pc_pmos_2
Xpmos_1_17 VDD VDD VDD GND VDD pc_pmos_1
Xpmos_1_28 m2_1218_35439# VDD VCTRLP GND VDD pc_pmos_1
Xpmos_2_5 irp VDD GND VCTRLP ipota pc_pmos_2
XpmosHV_2_0 VDD VDD GND VDD VDD pc_pmosHV_2
Xnmos_0 IBIAS GND GND it1 pc_nmos
Xpmos_1_18 V1_CM VDD V1_CM GND VDD pc_pmos_1
Xpmos_2_6 VDD VDD GND VDD VDD pc_pmos_2
XpmosHV_2_1 mp_dz VDD GND Vout VDD pc_pmosHV_2
Xnmos_1 IBIAS GND GND a_708_25739# pc_nmos
Xnmos_1_0 GND GND GND GND pc_nmos_1
Xpmos_1_19 a_19212_3770# VDD V1_CM GND VDD pc_pmos_1
Xnmos_2 IBIAS GND GND icm pc_nmos
XpmosHV_2_2 mp_dz VDD GND Vout VDD pc_pmosHV_2
Xnmos_1_1 m2_2394_32259# VDD GND GND pc_nmos_1
Xnmos_3 GND GND GND GND pc_nmos
XpmosHV_2_3 irn VDD GND irn VDD pc_pmosHV_2
Xnmos_1_2 a_19212_3770# V1_CM GND m2_2100_31899# pc_nmos_1
XpmosHV_2_4 mp_dz VDD GND Vout VDD pc_pmosHV_2
Xnmos_4 IBIAS GND GND icm pc_nmos
Xnmos_1_3 GND GND GND GND pc_nmos_1
XnmosHV_0 m3_16160_800# GND VCTRLP GND pc_nmosHV
XpmosHV_2_5 mp_dz VDD GND Vout VDD pc_pmosHV_2
Xnmos_5 IBIAS GND GND it1 pc_nmos
XnmosHV_1_0 VCTRLN irn GND inota pc_nmosHV_1
Xnmos_1_4 mp_dz Vo_STG1 GND m2_1806_31539# pc_nmos_1
XnmosHV_1 GND GND GND GND pc_nmosHV
XpmosHV_2_6 VDD VDD GND VDD VDD pc_pmosHV_2
Xnmos_6 IBIAS GND GND icm pc_nmos
XnmosHV_1_1 GND GND GND GND pc_nmosHV_1
Xnmos_1_5 V1_CM V1_CM GND GND pc_nmos_1
XnmosHV_2 GND GND GND GND pc_nmosHV
Xnmos_7 GND GND GND GND pc_nmos
XnmosHV_1_2 GND GND GND GND pc_nmosHV_1
Xnmos_1_6 a_18456_7060# V1_CM GND GND pc_nmos_1
XnmosHV_3 m3_16160_800# GND m3_16160_800# GND pc_nmosHV
Xnmos_8 IBIAS GND GND icm pc_nmos
XnmosHV_1_3 m3_16400_5410# a_19212_3770# GND inota pc_nmosHV_1
Xnmos_1_7 mn_dz Vo_STG1 GND GND pc_nmos_1
XnmosHV_4 m3_16160_800# GND m3_16160_800# GND pc_nmosHV
Xnmos_9 IBIAS GND GND it1 pc_nmos
XnmosHV_1_4 VCTRLN irn GND inota pc_nmosHV_1
Xnmos_1_8 V1_CM V1_CM GND m2_2394_32259# pc_nmos_1
Xnmos_20 IBIAS GND GND it1 pc_nmos
XnmosHV_5 m3_16160_800# GND VCTRLP GND pc_nmosHV
XnmosHV_1_5 m3_16400_5410# a_19212_3770# GND inota pc_nmosHV_1
Xrhigh_0 GND m2_17810_24119# Vo_STG1 rhigh_0/a_0_0# pc_rhigh
Xnmos_1_9 m2_1806_31539# VCTRLN GND GND pc_nmos_1
Xnmos_10 IBIAS GND GND it1 pc_nmos
Xnmos_21 IBIAS GND GND icm pc_nmos
Xnmos_1_10 m2_2100_31899# VCTRLN GND GND pc_nmos_1
Xrhigh_1 GND m2_17330_23939# m3_14960_18822# rhigh_1/a_0_0# pc_rhigh
Xnmos_11 IBIAS GND GND it1 pc_nmos
Xnmos_22 IBIAS GND GND icm pc_nmos
Xrhigh_2 GND m2_17330_23939# m2_18770_20752# rhigh_2/a_0_0# pc_rhigh
Xnmos_12 GND GND GND GND pc_nmos
Xnmos_23 IBIAS GND GND it1 pc_nmos
Xrhigh_3 GND m2_17810_24119# m2_18290_20572# rhigh_3/a_0_0# pc_rhigh
Xnmos_24 IBIAS GND GND inota pc_nmos
Xnmos_13 IBIAS GND GND it1 pc_nmos
Xpmos_0 a_708_25739# VDD GND VDD ipota pc_pmos
Xpmos_1_0 VDD VDD VDD GND VDD pc_pmos_1
Xrhigh_4 GND m2_19250_24299# a_20592_17400# rhigh_4/a_0_0# pc_rhigh
Xnmos_25 IBIAS GND GND icm pc_nmos
Xnmos_14 GND GND GND GND pc_nmos
Xpmos_1 a_708_25739# VDD GND VDD irp pc_pmos
Xpmos_1_1 a_18456_7060# VDD V1_CM GND m2_1218_35439# pc_pmos_1
Xrhigh_5 GND m2_19730_24479# a_20592_17400# rhigh_5/a_0_0# pc_rhigh
Xnmos_15 IBIAS GND GND icm pc_nmos
Xnmos_26 IBIAS GND GND icm pc_nmos
Xpmos_2 VDD VDD GND VDD VDD pc_pmos
Xpmos_1_2 mn_dz VDD Vo_STG1 GND m2_924_35079# pc_pmos_1
Xrhigh_6 GND m2_19730_24479# m2_18290_20572# rhigh_6/a_0_0# pc_rhigh
Xnmos_16 IBIAS GND GND it1 pc_nmos
Xnmos_27 IBIAS GND GND inota pc_nmos
Xpmos_3 a_708_25739# VDD GND VDD a_708_25739# pc_pmos
Xpmos_1_3 V1_CM VDD V1_CM GND m2_1512_35799# pc_pmos_1
Xrhigh_7 GND m2_19250_24299# m2_18770_20752# rhigh_7/a_0_0# pc_rhigh
Xnmos_17 IBIAS GND GND icm pc_nmos
Xnmos_28 IBIAS GND GND irn pc_nmos
XpmosHV_0 VDD VDD GND VDD VDD pc_pmosHV
Xpmos_4 a_708_25739# VDD GND VDD ipota pc_pmos
Xnmos_2_0 VCTRLN GND GND GND pc_nmos_2
Xpmos_1_4 a_18456_7060# VDD V1_CM GND m2_1218_35439# pc_pmos_1
Xnmos_29 IBIAS GND GND IBIAS pc_nmos
XpmosHV_1 m3_16400_5410# VDD GND m3_16400_5410# VDD pc_pmosHV
Xnmos_18 GND GND GND GND pc_nmos
Xpmos_5 VDD VDD GND VDD VDD pc_pmos
Xnmos_2_1 GND GND GND GND pc_nmos_2
Xpmos_1_5 mn_dz VDD Vo_STG1 GND m2_924_35079# pc_pmos_1
XpmosHV_1_0 VDD VDD VDD GND VDD pc_pmosHV_1
Xnmos_19 IBIAS GND GND it1 pc_nmos
XpmosHV_2 m3_16400_5410# VDD GND VCTRLN VDD pc_pmosHV
Xnmos_2_2 V1_CM GND a_21036_25739# icm pc_nmos_2
Xpmos_1_6 mn_dz VDD Vo_STG1 GND m2_924_35079# pc_pmos_1
XpmosHV_1_1 m3_14960_18822# a_21036_25739# VDD GND VDD pc_pmosHV_1
XpmosHV_3 VDD VDD GND VDD VDD pc_pmosHV
C0 m3_16160_800# VCTRLP 4.01408f
C1 inota icm 5.11489f
C2 rhigh_4/a_0_0# rhigh_5/a_0_0# 0.05253f
C3 m2_2394_32259# VDD 0.05056f
C4 m2_1512_35799# V1_CM 4.02518f
C5 ipota a_708_25739# 3.77182f
C6 m2_2394_32259# mp_dz 0.05237f
C7 minus IBIAS 5.10762f
C8 a_18456_7060# a_708_25739# 0.17492f
C9 a_20592_17400# it1 0.04519f
C10 m3_14960_18822# Vo_STG1 4.77606f
C11 IBIAS irn 0.12099f
C12 a_20592_17400# plus 0.06057f
C13 Vout it1 0.25356f
C14 rhigh_1/a_0_0# a_708_25739# 0.0159f
C15 m3_14960_18822# mn_dz 0.03272f
C16 plus Vout 6.9467f
C17 a_20592_17400# VCTRLN 2.13095f
C18 it1 VCTRLP 2.32621f
C19 VDD ipota 9.28843f
C20 Vout VCTRLN 0.99756f
C21 plus VCTRLP 0.0825f
C22 minus Vo_STG1 0.08734f
C23 it1 icm 16.96571f
C24 minus mn_dz 0.13793f
C25 Vout irp 2.57425f
C26 plus icm 0.08641f
C27 VCTRLN VCTRLP 8.29539f
C28 a_18456_7060# VDD 1.18907f
C29 VCTRLP irp 0.90103f
C30 Vo_STG1 irn 0.4209f
C31 VCTRLN icm 1.7178f
C32 irn mn_dz 0.70477f
C33 irp icm 0.04473f
C34 a_20592_17400# a_19212_3770# 0.09567f
C35 a_21036_25739# a_18456_7060# 2.15264f
C36 VCTRLP m2_924_35079# 0.01046f
C37 a_19212_3770# Vout 0.26997f
C38 a_18456_7060# mp_dz 0.89199f
C39 a_19212_3770# VCTRLP 0.96959f
C40 a_19212_3770# icm 0.0413f
C41 inota irn 0.47389f
C42 m3_16160_800# irn 0.05004f
C43 m2_2100_31899# V1_CM 0.04449f
C44 VDD a_708_25739# 15.29458f
C45 m2_1512_35799# mn_dz 0.17735f
C46 a_21036_25739# a_708_25739# 0.23057f
C47 VDD m2_17810_24119# 0.02536f
C48 m3_14960_18822# it1 0.50215f
C49 minus it1 0.08419f
C50 V1_CM IBIAS 0.1483f
C51 minus plus 7.86977f
C52 a_21036_25739# VDD 4.40043f
C53 it1 irn 2.6407f
C54 minus VCTRLN 0.4854f
C55 plus irn 0.03638f
C56 minus irp 0.08421f
C57 Vout ipota 0.18961f
C58 VDD mp_dz 3.31359f
C59 m2_1512_35799# m2_1218_35439# 0.54054f
C60 a_20592_17400# a_18456_7060# 0.306f
C61 m3_14960_18822# a_19212_3770# 0.12613f
C62 VCTRLP ipota 3.21889f
C63 VCTRLN irn 1.14023f
C64 a_18456_7060# Vout 0.25207f
C65 V1_CM Vo_STG1 8.86714f
C66 irn irp 4.33497f
C67 Vo_STG1 a_19668_25739# 0.38096f
C68 m2_1806_31539# V1_CM 0.8774f
C69 V1_CM mn_dz 0.31893f
C70 ipota icm 0.37521f
C71 a_18456_7060# VCTRLP 1.62943f
C72 mn_dz a_19668_25739# 0.79387f
C73 a_19212_3770# minus 0.13176f
C74 a_18456_7060# icm 0.04009f
C75 a_19212_3770# irn 1.3954f
C76 rhigh_3/a_0_0# rhigh_2/a_0_0# 0.05253f
C77 m2_2100_31899# m2_1806_31539# 0.10156f
C78 m2_2100_31899# mn_dz 0.03949f
C79 V1_CM m2_1218_35439# 0.11239f
C80 a_20592_17400# a_708_25739# 0.15049f
C81 Vout a_708_25739# 0.29872f
C82 VCTRLP a_708_25739# 0.34545f
C83 a_708_25739# icm 0.18425f
C84 m2_1512_35799# m2_924_35079# 0.22512f
C85 m3_16400_5410# inota 1.57359f
C86 rhigh_7/a_0_0# rhigh_6/a_0_0# 0.05253f
C87 IBIAS Vo_STG1 0.08423f
C88 m3_16160_800# m3_16400_5410# 1.04189f
C89 IBIAS mn_dz 0.089f
C90 VDD Vout 9.52417f
C91 a_20592_17400# a_21036_25739# 0.50726f
C92 m3_14960_18822# a_18456_7060# 0.11304f
C93 VDD VCTRLP 4.26642f
C94 V1_CM it1 0.07483f
C95 minus ipota 0.12296f
C96 plus V1_CM 2.62326f
C97 VDD icm 0.79623f
C98 Vout mp_dz 0.211f
C99 a_18456_7060# minus 0.12709f
C100 V1_CM VCTRLN 7.0951f
C101 inota IBIAS 0.38459f
C102 ipota irn 4.48432f
C103 Vo_STG1 mn_dz 0.22358f
C104 VCTRLP mp_dz 0.04979f
C105 a_21036_25739# icm 0.79025f
C106 V1_CM irp 0.083f
C107 m2_1806_31539# mn_dz 0.03959f
C108 a_18456_7060# irn 0.15099f
C109 V1_CM m2_924_35079# 0.34976f
C110 a_19212_3770# V1_CM 0.25938f
C111 a_19212_3770# a_19668_25739# 0.14514f
C112 rhigh_0/a_0_0# rhigh_3/a_0_0# 0.05253f
C113 m3_14960_18822# a_708_25739# 1.50827f
C114 m3_16400_5410# VCTRLN 2.31155f
C115 m3_16400_5410# irp 0.04413f
C116 mn_dz m2_1218_35439# 2.99177f
C117 minus a_708_25739# 0.19249f
C118 m2_17330_23939# m2_19250_24299# 0.06484f
C119 m2_2100_31899# a_19212_3770# 1.32864f
C120 m3_16160_800# inota 0.0536f
C121 m2_2394_32259# V1_CM 0.7956f
C122 irn a_708_25739# 0.19312f
C123 it1 IBIAS 2.46439f
C124 a_18456_7060# m2_1512_35799# 3.22778f
C125 a_19212_3770# m3_16400_5410# 0.30485f
C126 m3_14960_18822# VDD 1.20195f
C127 m2_19250_24299# m2_19730_24479# 0.4622f
C128 IBIAS VCTRLN 1.86017f
C129 m3_14960_18822# a_21036_25739# 0.78357f
C130 IBIAS irp 0.04253f
C131 VDD minus 0.2402f
C132 it1 Vo_STG1 0.71075f
C133 plus Vo_STG1 0.09269f
C134 m2_2100_31899# m2_2394_32259# 0.16341f
C135 Vout VCTRLP 0.19572f
C136 VDD irn 2.27142f
C137 it1 mn_dz 1.38537f
C138 a_20592_17400# icm 0.05438f
C139 rhigh_0/a_0_0# rhigh_1/a_0_0# 0.05253f
C140 minus mp_dz 0.08086f
C141 plus mn_dz 0.13143f
C142 a_19212_3770# IBIAS 0.08396f
C143 a_20592_17400# m2_18290_20572# 0.25448f
C144 Vout icm 0.13957f
C145 VCTRLN Vo_STG1 0.08901f
C146 Vo_STG1 irp 0.15153f
C147 VCTRLN mn_dz 0.82636f
C148 VCTRLP icm 3.746f
C149 V1_CM ipota 0.12052f
C150 irp mn_dz 2.4337f
C151 irn mp_dz 1.78678f
C152 a_18456_7060# V1_CM 4.59842f
C153 inota it1 2.96042f
C154 a_18456_7060# a_19668_25739# 0.14236f
C155 mn_dz m2_924_35079# 3.11695f
C156 a_19212_3770# Vo_STG1 0.1806f
C157 a_19212_3770# m2_1806_31539# 0.01797f
C158 inota VCTRLN 2.38802f
C159 a_19212_3770# mn_dz 0.13386f
C160 m3_16160_800# VCTRLN 0.16804f
C161 m3_16160_800# irp 0.03582f
C162 VDD m2_1512_35799# 2.48319f
C163 m2_2100_31899# a_18456_7060# 0.0404f
C164 m3_16400_5410# ipota 0.03834f
C165 a_19212_3770# inota 0.06561f
C166 a_19212_3770# m3_16160_800# 1.56311f
C167 a_18456_7060# m3_16400_5410# 0.04306f
C168 m2_1218_35439# m2_924_35079# 0.24962f
C169 m2_1512_35799# mp_dz 0.10394f
C170 m2_2394_32259# m2_1806_31539# 0.03634f
C171 V1_CM a_708_25739# 0.18106f
C172 m2_2394_32259# mn_dz 0.04197f
C173 m3_14960_18822# a_20592_17400# 0.66995f
C174 a_19668_25739# a_708_25739# 0.39579f
C175 IBIAS ipota 0.07637f
C176 a_20592_17400# minus 0.05996f
C177 plus it1 0.0794f
C178 m3_14960_18822# icm 1.51908f
C179 minus Vout 0.09174f
C180 it1 VCTRLN 1.77076f
C181 a_18456_7060# IBIAS 0.07816f
C182 it1 irp 3.32144f
C183 plus VCTRLN 0.38058f
C184 minus VCTRLP 0.08765f
C185 VDD V1_CM 2.24997f
C186 m2_17810_24119# m2_17330_23939# 0.41105f
C187 plus irp 0.07901f
C188 VDD a_19668_25739# 1.81059f
C189 Vout irn 2.43739f
C190 minus icm 0.09161f
C191 VCTRLP irn 1.24217f
C192 VCTRLN irp 1.38286f
C193 Vo_STG1 ipota 0.65401f
C194 rhigh_2/a_0_0# rhigh_7/a_0_0# 0.05253f
C195 m3_16400_5410# a_708_25739# 1.10594f
C196 a_21036_25739# a_19668_25739# 5.76214f
C197 irn icm 2.68125f
C198 V1_CM mp_dz 2.73432f
C199 a_19212_3770# it1 0.04048f
C200 VDD m2_17330_23939# 0.03613f
C201 a_18456_7060# Vo_STG1 0.16611f
C202 a_19212_3770# plus 0.12526f
C203 a_18456_7060# m2_1806_31539# 0.04064f
C204 a_18456_7060# mn_dz 5.93474f
C205 a_19212_3770# VCTRLN 1.24696f
C206 a_19212_3770# irp 0.13569f
C207 VDD m2_19730_24479# 0.04194f
C208 inota ipota 1.58427f
C209 a_20592_17400# m2_18770_20752# 0.28038f
C210 m3_16400_5410# VDD 2.27587f
C211 m3_16160_800# ipota 1.47508f
C212 IBIAS a_708_25739# 1.41339f
C213 m2_2100_31899# mp_dz 0.8928f
C214 a_18456_7060# m3_16160_800# 0.04496f
C215 m2_18770_20752# m2_18290_20572# 0.29687f
C216 a_18456_7060# m2_1218_35439# 3.54974f
C217 Vo_STG1 a_708_25739# 1.07241f
C218 VDD IBIAS 1.30604f
C219 mn_dz a_708_25739# 0.21167f
C220 m2_2394_32259# a_19212_3770# 0.97609f
C221 IBIAS mp_dz 0.07816f
C222 inota a_708_25739# 0.04333f
C223 it1 ipota 0.16081f
C224 VDD Vo_STG1 5.81822f
C225 a_20592_17400# V1_CM 2.12408f
C226 minus irn 0.04017f
C227 m3_16160_800# a_708_25739# 0.09263f
C228 plus ipota 0.11646f
C229 a_20592_17400# a_19668_25739# 0.09409f
C230 VDD mn_dz 1.2932f
C231 Vout V1_CM 6.79814f
C232 a_18456_7060# it1 0.03928f
C233 a_21036_25739# Vo_STG1 3.19066f
C234 VCTRLN ipota 1.03095f
C235 a_18456_7060# plus 0.12059f
C236 V1_CM VCTRLP 3.7206f
C237 ipota irp 2.76048f
C238 Vo_STG1 mp_dz 0.05421f
C239 m2_1806_31539# mp_dz 1.18496f
C240 V1_CM icm 0.09864f
C241 a_18456_7060# VCTRLN 1.44423f
C242 mn_dz mp_dz 1.7106f
C243 a_19668_25739# icm 0.87288f
C244 a_18456_7060# irp 1.27986f
C245 a_19668_25739# m2_18290_20572# 0.05599f
C246 VDD inota 0.40498f
C247 m3_16160_800# VDD 0.56429f
C248 a_18456_7060# m2_924_35079# 0.05329f
C249 a_19212_3770# ipota 0.03556f
C250 VDD m2_1218_35439# 2.48792f
C251 a_18456_7060# a_19212_3770# 7.48935f
C252 m3_16400_5410# VCTRLP 0.61615f
C253 it1 a_708_25739# 0.55822f
C254 plus a_708_25739# 0.18315f
C255 VCTRLN a_708_25739# 1.67952f
C256 irp a_708_25739# 0.27957f
C257 Vout IBIAS 0.06458f
C258 m2_2394_32259# a_18456_7060# 0.04286f
C259 IBIAS VCTRLP 1.77275f
C260 VDD it1 2.25054f
C261 rhigh_5/a_0_0# rhigh_6/a_0_0# 0.05253f
C262 VDD plus 0.23052f
C263 IBIAS icm 0.87899f
C264 a_19212_3770# a_708_25739# 1.04313f
C265 m3_14960_18822# a_19668_25739# 2.10649f
C266 a_20592_17400# Vo_STG1 0.36394f
C267 VDD VCTRLN 10.85464f
C268 VDD irp 6.19548f
C269 Vout Vo_STG1 0.26155f
C270 a_20592_17400# mn_dz 0.08195f
C271 minus V1_CM 0.26743f
C272 plus mp_dz 0.07816f
C273 Vout mn_dz 0.29783f
C274 VCTRLP Vo_STG1 3.81587f
C275 VDD m2_924_35079# 5.38836f
C276 VCTRLP mn_dz 0.09805f
C277 V1_CM irn 0.04043f
C278 Vo_STG1 icm 0.38493f
C279 Vo_STG1 m2_18290_20572# 0.0592f
C280 mn_dz icm 0.04974f
C281 a_19212_3770# VDD 2.27023f
C282 a_18456_7060# ipota 0.05035f
C283 Vout inota 0.68006f
C284 a_21036_25739# a_19212_3770# 0.12437f
C285 VDD m2_19250_24299# 0.05394f
C286 inota VCTRLP 1.09635f
C287 a_19212_3770# mp_dz 4.10427f
C288 Vout GND 6.11591f
C289 plus GND 1.11781f
C290 minus GND 2.71294f
C291 VDD GND 52.18299f
C292 m3_16400_5410# GND 2.59371f
C293 m3_16160_800# GND 6.2687f
C294 a_19212_3770# GND 7.2523f
C295 a_18456_7060# GND 4.96852f
C296 a_21036_25739# GND 3.24445f
C297 a_20592_17400# GND 2.197f
C298 m3_14960_18822# GND 2.83816f
C299 a_19668_25739# GND 3.82043f
C300 mp_dz GND 3.49035f
C301 mn_dz GND 12.35593f
C302 irp GND 5.41731f
C303 irn GND 6.85499f
C304 ipota GND 3.6908f
C305 Vo_STG1 GND 11.74218f
C306 VCTRLP GND 14.42167f
C307 VCTRLN GND 8.03139f
C308 IBIAS GND 62.22792f
C309 m2_18290_20572# GND 0.60844f
C310 m2_18770_20752# GND 0.20599f
C311 V1_CM GND 11.4575f
C312 m2_924_35079# GND 0.29034f
C313 m2_1218_35439# GND 0.96612f
C314 m2_19250_24299# GND 1.03059f
C315 m2_1512_35799# GND 1.71876f
C316 m2_19730_24479# GND 0.74422f
C317 inota GND 5.88814f
C318 it1 GND 29.32178f
C319 m2_17330_23939# GND 0.78538f
C320 m2_17810_24119# GND 0.54089f
C321 m2_2394_32259# GND 2.155f
C322 icm GND 26.00437f
C323 m2_1806_31539# GND 1.54849f
C324 m2_2100_31899# GND 1.68544f
C325 a_708_25739# GND 9.42993f
.ends
